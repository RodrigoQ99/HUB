; film visibility helpers for artwork setup (Claude)
CQDIR = "C:/Users/Maria Priscila Quiro/OneDrive/Documentos/Escritorio/Orcad/cdssetup/workspace/projects/hub/"
cqFilms = list(
  list("L1_TOP"      list("ETCH/TOP" "PIN/TOP" "VIA CLASS/TOP" "BOARD GEOMETRY/OUTLINE" "BOARD GEOMETRY/DESIGN_OUTLINE"))
  list("L2_GND"      list("ETCH/GND" "PIN/GND" "VIA CLASS/GND" "BOARD GEOMETRY/OUTLINE" "BOARD GEOMETRY/DESIGN_OUTLINE"))
  list("L3_PWR"      list("ETCH/PWR" "PIN/PWR" "VIA CLASS/PWR" "BOARD GEOMETRY/OUTLINE" "BOARD GEOMETRY/DESIGN_OUTLINE"))
  list("L4_BOTTOM"   list("ETCH/BOTTOM" "PIN/BOTTOM" "VIA CLASS/BOTTOM" "BOARD GEOMETRY/OUTLINE" "BOARD GEOMETRY/DESIGN_OUTLINE"))
  list("SILK_TOP"    list("BOARD GEOMETRY/SILKSCREEN_TOP" "PACKAGE GEOMETRY/SILKSCREEN_TOP" "REF DES/SILKSCREEN_TOP" "BOARD GEOMETRY/OUTLINE" "BOARD GEOMETRY/DESIGN_OUTLINE"))
  list("SILK_BOTTOM" list("BOARD GEOMETRY/SILKSCREEN_BOTTOM" "PACKAGE GEOMETRY/SILKSCREEN_BOTTOM" "REF DES/SILKSCREEN_BOTTOM" "BOARD GEOMETRY/OUTLINE" "BOARD GEOMETRY/DESIGN_OUTLINE"))
  list("MASK_TOP"    list("BOARD GEOMETRY/SOLDERMASK_TOP" "PACKAGE GEOMETRY/SOLDERMASK_TOP" "PIN/SOLDERMASK_TOP" "VIA CLASS/SOLDERMASK_TOP"))
  list("MASK_BOTTOM" list("BOARD GEOMETRY/SOLDERMASK_BOTTOM" "PACKAGE GEOMETRY/SOLDERMASK_BOTTOM" "PIN/SOLDERMASK_BOTTOM" "VIA CLASS/SOLDERMASK_BOTTOM"))
  list("PASTE_TOP"   list("PACKAGE GEOMETRY/PASTEMASK_TOP" "PIN/PASTEMASK_TOP"))
  list("PASTE_BOTTOM" list("PACKAGE GEOMETRY/PASTEMASK_BOTTOM" "PIN/PASTEMASK_BOTTOM"))
  list("ASSY_TOP"    list("PACKAGE GEOMETRY/ASSEMBLY_TOP" "REF DES/ASSEMBLY_TOP" "COMPONENT VALUE/ASSEMBLY_TOP" "BOARD GEOMETRY/OUTLINE" "BOARD GEOMETRY/DESIGN_OUTLINE"))
  list("ASSY_BOTTOM" list("PACKAGE GEOMETRY/ASSEMBLY_BOTTOM" "REF DES/ASSEMBLY_BOTTOM" "COMPONENT VALUE/ASSEMBLY_BOTTOM" "BOARD GEOMETRY/OUTLINE" "BOARD GEOMETRY/DESIGN_OUTLINE"))
  list("OUTLINE"     list("BOARD GEOMETRY/OUTLINE" "BOARD GEOMETRY/DESIGN_OUTLINE" "BOARD GEOMETRY/DIMENSION"))
  list("DRILL_DWG"   list("MANUFACTURING/NCLEGEND-1-4" "BOARD GEOMETRY/OUTLINE" "BOARD GEOMETRY/DESIGN_OUTLINE")))
procedure(cqVis(name)
  let((e ok)
    e = assoc(name cqFilms)
    axlVisibleDesign(nil)
    foreach(l cadr(e) ok = car(errset(axlVisibleLayer(l t) nil)) unless(ok printf("  (no layer %s)\n" l)))
    axlVisibleUpdate(t)
    printf("visible for %s\n" name) t))
printf("c57 loaded: cqVis(\"L1_TOP\") ...\n")
