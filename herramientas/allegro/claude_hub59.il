; auto-routed etch from Claude grid router (r59)
CQDIR = "C:/Users/Maria Priscila Quiro/OneDrive/Documentos/Escritorio/Orcad/cdssetup/workspace/projects/hub/"
procedure(cqP(lay net w x0 y0 x1 y1)
  let((p r) p = axlPathStart(list(x0:y0) w) axlPathLine(p w x1:y1)
    r = car(errset(axlDBCreatePath(p lay net nil) t))
    if(r then cqNP = cqNP + 1 else cqEP = cons(list(net x0 y0 x1 y1) cqEP))))
procedure(cqV(ps x y net)
  let((r) r = car(errset(axlDBCreateVia(ps x:y net) t))
    if(r then cqNV = cqNV + 1 else cqEV = cons(list(net x y) cqEV))))
cqNP = 0 cqNV = 0 cqEP = nil cqEV = nil
procedure(cqRoute_r59()
  axlDBRefreshId(nil)
  cqV("via" 86.8500 78.8500 "GND")
  cqV("via" 86.8500 80.0000 "GND")
  cqV("via" 86.8500 81.1500 "GND")
  cqV("via" 88.0000 78.8500 "GND")
  cqV("via" 88.0000 80.0000 "GND")
  cqV("via" 88.0000 81.1500 "GND")
  cqV("via" 89.1500 78.8500 "GND")
  cqV("via" 89.1500 80.0000 "GND")
  cqV("via" 89.1500 81.1500 "GND")
  cqV("via" 112.4500 59.2000 "GND")
  cqV("via" 113.2500 59.2000 "GND")
  cqV("via" 67.2000 61.6000 "GND")
  cqV("via" 68.0000 61.6000 "GND")
  cqV("via" 60.0000 61.6000 "GND")
  cqV("via" 60.8000 61.6000 "GND")
  cqV("via" 62.2000 99.6000 "GND")
  cqV("via" 63.0000 99.6000 "GND")
  cqV("VIA02B" 85.0000 84.6000 "VDD33")
  cqV("via" 91.2000 84.1500 "VDD33")
  cqV("via" 91.1500 83.2000 "VDD12")
  cqV("via" 92.5000 78.2000 "VDD33")
  cqV("via" 91.1500 76.2500 "VDD12")
  cqV("via" 84.9000 75.9500 "VDD33")
  cqV("via" 92.3000 100.7500 "GND")
  cqV("via" 85.7000 100.7500 "GND")
  cqV("via" 59.2500 92.3000 "GND")
  cqV("via" 59.2500 85.7000 "GND")
  cqV("via" 59.2500 74.3000 "GND")
  cqV("via" 59.2500 67.7000 "GND")
  cqV("via" 75.7000 59.2500 "GND")
  cqV("via" 82.3000 59.2500 "GND")
  cqV("via" 93.7000 59.2500 "GND")
  cqV("via" 100.3000 59.2500 "GND")
  cqV("via" 79.9000 90.5500 "GND")
  cqV("via" 82.0000 88.8000 "GND")
  cqV("via" 111.6500 79.3000 "GND")
  cqV("via" 112.7000 60.9000 "GND")
  cqV("via" 67.4500 63.3000 "GND")
  cqV("via" 60.2500 63.3000 "GND")
  cqV("via" 62.4500 101.3000 "GND")
  cqV("via" 103.4000 82.1000 "GND")
  cqV("via" 98.1500 77.7500 "GND")
  cqV("via" 93.9000 96.2500 "GND")
  cqV("via" 93.9000 97.9500 "GND")
  cqV("via" 110.6000 85.5500 "GND")
  cqV("via" 120.7500 92.3000 "GND")
  cqV("via" 62.8500 61.5000 "GND")
  cqV("via" 115.0500 59.5000 "GND")
  cqV("via" 64.6000 62.1000 "GND")
  cqV("via" 119.1500 79.9500 "GND")
  cqV("via" 95.2500 81.1000 "GND")
  cqV("via" 72.1500 61.1000 "GND")
  cqV("via" 54.3000 81.1500 "GND")
  cqV("via" 54.3000 82.9500 "GND")
  cqV("via" 104.0500 60.9500 "GND")
  cqV("via" 80.8500 105.3000 "GND")
  cqV("via" 109.5000 82.0500 "GND")
  cqV("via" 65.0500 98.7000 "GND")
  cqV("via" 82.1500 83.3000 "GND")
  cqV("via" 82.6500 91.2000 "GND")
  cqV("via" 133.5500 97.4000 "GND")
  cqV("via" 147.4000 65.2000 "GND")
  cqV("via" 157.4000 66.2500 "GND")
  cqV("via" 97.5000 106.1000 "GND")
  cqV("via" 114.6000 52.3000 "GND")
  cqV("via" 62.9500 54.9500 "GND")
  cqV("via" 53.1500 63.1500 "GND")
  cqV("via" 62.6000 105.9000 "GND")
  cqV("via" 127.1500 80.3500 "GND")
  cqV("via" 85.4500 70.7000 "GND")
  cqV("via" 90.7500 89.2000 "GND")
  cqV("via" 95.4000 87.3500 "GND")
  cqV("via" 95.4000 85.5500 "GND")
  cqV("via" 97.7000 103.8500 "GND")
  cqV("via" 95.8000 100.9000 "GND")
  cqV("via" 78.4000 89.5000 "GND")
  cqV("via" 78.4000 86.6500 "GND")
  cqV("via" 72.6500 64.1000 "GND")
  cqV("via" 57.5000 81.1500 "GND")
  cqV("via" 86.2000 86.5500 "GND")
  cqV("via" 88.5500 86.5000 "GND")
  cqV("via" 93.5500 78.9000 "GND")
  cqV("via" 97.2000 78.4500 "GND")
  cqV("via" 91.1500 86.4000 "GND")
  cqV("via" 89.8500 73.4000 "GND")
  cqV("via" 88.2500 73.6000 "GND")
  cqV("via" 84.5000 75.0500 "GND")
  cqV("via" 82.2500 76.9000 "GND")
  cqV("via" 103.8000 84.1500 "GND")
  cqV("via" 57.6000 82.0500 "GND")
  cqV("via" 113.7000 62.9500 "GND")
  cqV("via" 61.5000 58.9500 "GND")
  cqV("via" 68.7000 65.1500 "GND")
  cqV("via" 108.8500 61.5000 "GND")
  cqV("via" 57.7000 62.9500 "GND")
  cqV("via" 70.2500 61.7000 "GND")
  cqV("via" 63.1000 103.3500 "GND")
  cqV("via" 118.7000 84.8000 "GND")
  cqV("via" 79.0500 105.3000 "GND")
  cqV("via" 96.2000 78.2000 "GND")
  cqV("via" 105.9000 61.5000 "GND")
  cqV("via" 87.5000 73.3500 "GND")
  cqV("via" 61.3500 97.1000 "GND")
  cqV("via" 138.3000 90.3000 "GND")
  cqV("via" 148.3000 80.1000 "GND")
  cqV("via" 134.2000 62.9000 "GND")
  cqV("via" 144.6000 64.6500 "GND")
  cqV("via" 144.6000 70.8000 "GND")
  cqV("via" 144.6000 72.6000 "GND")
  cqV("via" 153.4000 68.2000 "GND")
  cqV("via" 146.8000 51.8000 "GND")
  cqV("via" 123.7000 78.7000 "GND")
  cqV("via" 103.0000 102.6000 "GND")
  cqV("via" 135.3500 64.6500 "GND")
  cqV("via" 140.8000 76.4500 "GND")
  cqV("via" 138.5000 76.4500 "GND")
  cqV("via" 143.1000 78.7500 "GND")
  cqV("via" 140.8000 78.7500 "GND")
  cqV("via" 138.5000 78.7500 "GND")
  cqV("via" 136.2000 78.7500 "GND")
  cqV("via" 140.8000 81.0500 "GND")
  cqV("via" 138.5000 81.0500 "GND")
  cqV("via" 136.2000 81.0500 "GND")
  cqV("via" 140.8000 83.3500 "GND")
  cqV("via" 138.5000 83.3500 "GND")
  cqV("via" 136.2000 83.3500 "GND")
  cqV("via" 133.6000 85.1000 "GND")
  cqV("via" 140.8000 85.6000 "GND")
  cqV("via" 138.5000 85.6000 "GND")
  cqV("via" 134.0500 89.9500 "GND")
  cqV("via" 134.0500 92.9500 "GND")
  cqV("via" 149.7500 85.4500 "GND")
  cqV("via" 149.7500 82.4500 "GND")
  cqV("via" 156.2500 58.4500 "GND")
  cqV("via" 156.2500 55.4500 "GND")
  cqV("via" 134.0500 66.4000 "GND")
  cqV("via" 144.8500 68.6000 "GND")
  cqV("via" 156.2500 70.1000 "GND")
  cqV("via" 150.7000 65.7500 "GND")
  cqV("via" 154.2500 51.3000 "GND")
  cqV("via" 150.1000 51.3000 "GND")
  cqV("via" 111.7500 60.7500 "5V")
  cqV("via" 66.5000 63.1500 "5V")
  cqV("via" 59.3000 63.1500 "5V")
  cqV("via" 61.5000 101.1500 "5V")
  cqV("via" 111.8000 61.7000 "5V")
  cqV("via" 66.8000 63.9000 "5V")
  cqV("via" 55.8000 61.7000 "5V")
  cqV("via" 61.2000 102.1000 "5V")
  cqV("via" 147.2500 80.1000 "5V")
  cqV("via" 143.1000 81.0500 "5V")
  cqV("via" 143.1000 83.3500 "5V")
  cqV("via" 144.4000 85.7500 "5V")
  cqV("via" 146.4500 85.4500 "5V")
  cqV("via" 146.4500 82.4500 "5V")
  cqV("via" 130.6000 69.6000 "5V")
  cqV("via" 151.6000 70.1000 "5V")
  cqV("via" 95.4000 77.7500 "N10087")
  cqV("via" 113.5000 60.9000 "N10087")
  cqV("via" 59.6000 90.1000 "PWR1")
  cqV("via" 59.6000 72.1000 "PWR2")
  cqV("via" 57.2000 77.9000 "PWR2")
  cqV("via" 59.1500 61.0000 "PWR2")
  cqV("via" 54.1000 60.9000 "PWR2")
  cqV("via" 95.9000 59.6000 "PWR4")
  cqV("via" 90.1000 100.4000 "UP_VBUS")
  cqV("via" 94.6000 87.5500 "UP_VBUS")
  cqV("VIA02B" 94.8000 82.8000 "UP_VBUS")
  cqV("via" 135.0500 98.8000 "N3269173")
  cqV("via" 136.9500 97.4000 "N3269173")
  cqV("via" 62.2000 62.1000 "N10630")
  cqV("via" 62.7500 63.4500 "N10630")
  cqV("via" 76.5500 60.7500 "DN3_CC2")
  cqV("via" 59.6000 88.3500 "DN1_CC1")
  cqV("via" 61.0500 91.3500 "DN1_CC1")
  cqV("via" 79.6500 59.6000 "DN3_CC1")
  cqV("via" 77.0500 60.1500 "DN3_CC1")
  cqV("via" 106.1500 83.6000 "N34960")
  cqV("via" 106.1500 86.0000 "N34960")
  cqV("via" 88.3000 100.4000 "UP_CC1")
  cqV("via" 91.5500 97.6500 "UP_CC1")
  cqV("via" 108.0000 80.8000 "N33797")
  cqV("via" 105.9500 79.7500 "N33797")
  cqV("via" 55.1500 78.8000 "DN2_CC2")
  cqV("via" 146.8500 66.6000 "N328103")
  cqV("via" 142.8000 66.6000 "N328103")
  cqV("via" 92.5500 104.1500 "UP_CC2")
  cqV("via" 92.5000 96.4000 "UP_CC2")
  cqV("via" 64.5500 92.3000 "DN1_CC2")
  cqV("via" 101.0500 102.2000 "N30428")
  cqV("via" 99.1000 106.1000 "N30428")
  cqV("via" 98.2500 59.7500 "DN4_CC1")
  cqV("via" 105.3000 62.3500 "DN4_CC1")
  cqV("via" 59.6000 70.3500 "DN2_CC1")
  cqV("via" 60.2500 71.7000 "DN2_CC1")
  cqV("via" 106.9500 83.1500 "N42024")
  cqV("via" 110.1000 86.5500 "N42024")
  cqV("via" 112.6500 102.6500 "N32206")
  cqV("via" 98.4000 55.4000 "DN4_CC2")
  cqV("via" 107.5500 60.4000 "DN4_CC2")
  cqV("via" 108.2000 61.9500 "DN4_CC2")
  cqV("via" 106.9000 79.1000 "N33785")
  cqV("via" 97.6500 81.3000 "N33785")
  cqV("via" 111.8000 82.6500 "N34925")
  cqV("via" 109.6000 84.0000 "N34925")
  cqV("via" 111.9500 81.8500 "N26306")
  cqV("via" 97.7000 82.4500 "N26306")
  cqV("via" 106.1500 81.5000 "N41897")
  cqV("via" 120.2500 93.3000 "N41897")
  cqV("via" 139.8500 65.7500 "EN3")
  cqV("via" 155.3000 66.2500 "EN3")
  cqV("via" 97.0000 82.7500 "N30235")
  cqV("via" 101.8000 102.4500 "N30235")
  cqV("via" 146.2000 57.0500 "3V3")
  cqV("via" 146.0000 55.2000 "3V3")
  cqV("via" 77.8500 59.6000 "PWR3")
  cqV("via" 73.4500 60.3500 "PWR3")
  cqV("via" 71.4500 58.9500 "PWR3")
  cqV("via" 69.0500 60.6500 "PWR3")
  cqV("via" 66.3500 60.7000 "PWR3")
  cqV("VIA02B" 92.1500 79.2000 "N09603")
  cqV("via" 70.1000 63.5000 "N09603")
  cqV("via" 82.1000 103.4000 "GND_EARTH")
  cqV("via" 62.4500 93.6000 "GND_EARTH")
  cqV("via" 56.1500 87.7500 "GND_EARTH")
  cqV("via" 55.2000 82.8500 "GND_EARTH")
  cqV("via" 53.1500 81.7500 "GND_EARTH")
  cqV("via" 56.1500 69.7500 "GND_EARTH")
  cqV("via" 65.4000 67.4500 "GND_EARTH")
  cqV("via" 72.5000 62.7000 "GND_EARTH")
  cqV("via" 80.2500 56.1500 "GND_EARTH")
  cqV("via" 98.2500 56.1500 "GND_EARTH")
  cqV("via" 103.3000 56.6500 "GND_EARTH")
  cqV("VIA02B" 92.6500 84.8500 "VDD12")
  cqV("via" 92.4000 86.4000 "VDD12")
  cqV("via" 91.2000 85.2000 "VDD12")
  cqV("VIA02B" 85.3500 82.4500 "VDD12")
  cqV("VIA02B" 84.9000 76.9000 "VDD12")
  cqV("VIA02B" 92.0500 74.6000 "VDD12")
  cqV("via" 90.8500 72.3500 "VDD12")
  cqV("via" 89.1000 73.3000 "VDD12")
  cqV("via" 148.1000 57.7500 "VDD12")
  cqV("via" 63.8500 99.2500 "N08722")
  cqV("via" 64.9000 100.8000 "N08722")
  cqV("VIA02B" 93.6500 84.2500 "RESET_N")
  cqV("via" 139.9500 64.0500 "RESET_N")
  cqV("VIA02B" 93.5000 79.6000 "N10586")
  cqV("via" 64.1000 62.7000 "N10586")
  cqV("VIA02B" 92.4000 76.5500 "VDD33")
  cqV("VIA02B" 92.5000 74.1500 "VDD33")
  cqV("via" 90.0500 71.8500 "VDD33")
  cqV("via" 86.5000 72.2000 "VDD33")
  cqV("via" 101.7500 72.6000 "VDD33")
  cqV("via" 113.8500 71.7000 "VDD33")
  cqV("via" 143.0500 71.7000 "VDD33")
  cqV("via" 147.1500 72.1500 "VDD33")
  cqV("VIA02B" 93.7500 80.1500 "N08734")
  cqV("via" 66.3000 99.8000 "N08734")
  cqP("ETCH/TOP" "TESTEN" 0.1270 87.0000 83.4000 87.0000 84.1780)
  cqP("ETCH/TOP" "TESTEN" 0.1270 87.0000 84.1780 84.5600 86.6180)
  cqP("ETCH/TOP" "TESTEN" 0.1270 84.5600 86.6180 84.5600 91.9000)
  cqP("ETCH/TOP" "TESTEN" 0.1270 84.5600 91.9000 83.9500 91.9000)
  cqP("ETCH/TOP" "N208498" 0.1270 86.6000 83.4000 86.6000 84.1530)
  cqP("ETCH/TOP" "N208498" 0.1270 86.6000 84.1530 84.2600 86.4930)
  cqP("ETCH/TOP" "N208498" 0.1270 84.2600 86.4930 84.2600 89.6500)
  cqP("ETCH/TOP" "N208498" 0.1270 84.2600 89.6500 83.1000 89.6500)
  cqP("ETCH/TOP" "N210668" 0.1270 86.2000 83.4000 86.2000 84.1290)
  cqP("ETCH/TOP" "N210668" 0.1270 86.2000 84.1290 83.3790 86.9500)
  cqP("ETCH/TOP" "N210668" 0.1270 83.3790 86.9500 81.3000 86.9500)
  cqP("ETCH/TOP" "N210668" 0.1270 81.3000 86.9500 80.9000 87.9500)
  cqP("ETCH/TOP" "RBIAS" 0.1270 85.4000 83.4000 85.4000 84.0000)
  cqP("ETCH/TOP" "RBIAS" 0.1270 85.4000 84.0000 83.4500 84.0000)
  cqP("ETCH/TOP" "VDD33" 0.1270 85.8000 83.4000 85.8000 84.1500)
  cqP("ETCH/TOP" "VDD33" 0.1270 85.8000 84.1500 85.3500 84.6000)
  cqP("ETCH/TOP" "VDD33" 0.1270 85.3500 84.6000 85.0000 84.6000)
  cqP("ETCH/TOP" "N18966" 0.1270 91.4000 82.2000 92.2500 82.2000)
  cqP("ETCH/TOP" "N18966" 0.1270 92.2500 82.2000 94.2500 84.2000)
  cqP("ETCH/TOP" "N18966" 0.1270 94.2500 84.2000 100.9000 84.2000)
  cqP("ETCH/TOP" "N18966" 0.1270 100.9000 84.2000 100.9000 80.2749)
  cqP("ETCH/TOP" "N18966" 0.1270 100.9000 80.2749 104.6702 80.2749)
  cqP("ETCH/TOP" "N18954" 0.1270 91.4000 81.8000 92.2740 81.8000)
  cqP("ETCH/TOP" "N18954" 0.1270 92.2740 81.8000 94.3740 83.9000)
  cqP("ETCH/TOP" "N18954" 0.1270 94.3740 83.9000 100.6000 83.9000)
  cqP("ETCH/TOP" "N18954" 0.1270 100.6000 83.9000 100.6000 78.3242)
  cqP("ETCH/TOP" "N18954" 0.1270 100.6000 78.3242 104.6702 78.3242)
  cqP("ETCH/TOP" "N18947" 0.1270 91.4000 81.4000 92.2990 81.4000)
  cqP("ETCH/TOP" "N18947" 0.1270 92.2990 81.4000 94.4990 83.6000)
  cqP("ETCH/TOP" "N18947" 0.1270 94.4990 83.6000 100.3000 83.6000)
  cqP("ETCH/TOP" "N18947" 0.1270 100.3000 83.6000 100.3000 78.9744)
  cqP("ETCH/TOP" "N18947" 0.1270 100.3000 78.9744 98.9298 78.9744)
  cqP("ETCH/TOP" "N18933" 0.1270 91.4000 81.0000 92.3230 81.0000)
  cqP("ETCH/TOP" "N18933" 0.1270 92.3230 81.0000 94.6230 83.3000)
  cqP("ETCH/TOP" "N18933" 0.1270 94.6230 83.3000 100.0000 83.3000)
  cqP("ETCH/TOP" "N18933" 0.1270 100.0000 83.3000 100.0000 80.9251)
  cqP("ETCH/TOP" "N18933" 0.1270 100.0000 80.9251 98.9298 80.9251)
  cqP("ETCH/TOP" "VBUS_DET" 0.1270 91.4000 80.6000 93.9000 80.6000)
  cqP("ETCH/TOP" "VBUS_DET" 0.1270 93.9000 80.6000 94.4540 80.3980)
  cqP("ETCH/TOP" "VBUS_DET" 0.1270 94.4540 80.3980 94.4540 78.5470)
  cqP("ETCH/TOP" "VBUS_DET" 0.1270 94.4540 80.3980 94.4540 81.3000)
  cqP("ETCH/TOP" "VBUS_DET" 0.1270 94.4540 81.3000 95.5208 82.1980)
  cqP("ETCH/BOTTOM" "VDD33" 0.2000 85.0000 84.6000 85.4980 84.7540)
  cqP("ETCH/TOP" "N210668" 0.2000 80.9000 87.9500 78.6530 88.4208)
  cqP("ETCH/TOP" "N208498" 0.2000 83.1000 89.6500 81.6500 91.0000)
  cqP("ETCH/TOP" "N208498" 0.2000 81.6500 91.0000 78.6530 91.2708)
  cqP("ETCH/TOP" "VDD33" 0.2000 90.2000 83.4000 90.2500 84.3500)
  cqP("ETCH/TOP" "VDD33" 0.2000 90.2500 84.3500 90.9500 84.4000)
  cqP("ETCH/TOP" "VDD33" 0.2000 90.9500 84.4000 91.2000 84.1500)
  cqP("ETCH/TOP" "VDD12" 0.2000 90.6000 83.4000 91.1500 83.2000)
  cqP("ETCH/TOP" "VDD33" 0.2500 91.4000 78.2000 92.5000 78.2000)
  cqP("ETCH/TOP" "VDD12" 0.2000 90.6000 76.6000 91.1500 76.2500)
  cqP("ETCH/TOP" "VDD33" 0.2000 85.8000 76.6000 85.7500 76.0000)
  cqP("ETCH/TOP" "VDD33" 0.2000 85.7500 76.0000 84.9000 75.9500)
  cqP("ETCH/TOP" "GND" 0.4000 91.7500 101.2700 92.3000 100.7500)
  cqP("ETCH/TOP" "GND" 0.4000 86.2500 101.2700 85.7000 100.7500)
  cqP("ETCH/TOP" "GND" 0.4000 58.7300 91.7500 59.2500 92.3000)
  cqP("ETCH/TOP" "GND" 0.4000 58.7300 86.2500 59.2500 85.7000)
  cqP("ETCH/TOP" "GND" 0.4000 58.7300 73.7500 59.2500 74.3000)
  cqP("ETCH/TOP" "GND" 0.4000 58.7300 68.2500 59.2500 67.7000)
  cqP("ETCH/TOP" "GND" 0.4000 76.2500 58.7300 75.7000 59.2500)
  cqP("ETCH/TOP" "GND" 0.4000 81.7500 58.7300 82.3000 59.2500)
  cqP("ETCH/TOP" "GND" 0.4000 94.2500 58.7300 93.7000 59.2500)
  cqP("ETCH/TOP" "GND" 0.4000 99.7500 58.7300 100.3000 59.2500)
  cqP("ETCH/TOP" "GND" 0.4000 80.9000 89.6500 79.9000 90.5500)
  cqP("ETCH/TOP" "GND" 0.4000 83.1000 87.9500 82.0000 88.8000)
  cqP("ETCH/TOP" "GND" 0.4000 110.7235 78.6950 111.6500 79.3000)
  cqP("ETCH/TOP" "GND" 0.4000 112.8500 60.1600 112.7000 60.9000)
  cqP("ETCH/TOP" "GND" 0.4000 67.6000 62.5600 67.4500 63.3000)
  cqP("ETCH/TOP" "GND" 0.4000 60.4000 62.5600 60.2500 63.3000)
  cqP("ETCH/TOP" "GND" 0.4000 62.6000 100.5600 62.4500 101.3000)
  cqP("ETCH/TOP" "GND" 0.4000 104.6702 82.2256 103.4000 82.1000)
  cqP("ETCH/TOP" "GND" 0.4000 98.9298 78.3242 98.1500 77.7500)
  cqP("ETCH/TOP" "GND" 0.4000 93.3208 95.6980 93.9000 96.2500)
  cqP("ETCH/TOP" "GND" 0.4000 93.3208 97.3980 93.9000 97.9500)
  cqP("ETCH/TOP" "GND" 0.4000 110.8400 86.2500 110.6000 85.5500)
  cqP("ETCH/TOP" "GND" 0.4000 121.0000 93.0000 120.7500 92.3000)
  cqP("ETCH/TOP" "GND" 0.4000 63.4020 60.9208 62.8500 61.5000)
  cqP("ETCH/TOP" "GND" 0.4000 115.6020 58.9208 115.0500 59.5000)
  cqP("ETCH/TOP" "GND" 0.4000 65.1530 61.5208 64.6000 62.1000)
  cqP("ETCH/TOP" "GND" 0.4000 118.5708 79.3980 119.1500 79.9500)
  cqP("ETCH/TOP" "GND" 0.4000 95.5208 80.3980 95.2500 81.1000)
  cqP("ETCH/TOP" "GND" 0.4000 72.7030 60.5208 72.1500 61.1000)
  cqP("ETCH/TOP" "GND" 0.4000 53.7208 80.5970 54.3000 81.1500)
  cqP("ETCH/TOP" "GND" 0.4000 53.7208 82.3980 54.3000 82.9500)
  cqP("ETCH/TOP" "GND" 0.4000 104.6020 60.3708 104.0500 60.9500)
  cqP("ETCH/TOP" "GND" 0.4000 81.4030 104.7208 80.8500 105.3000)
  cqP("ETCH/TOP" "GND" 0.4000 108.9208 81.4980 109.5000 82.0500)
  cqP("ETCH/TOP" "GND" 0.4000 65.6020 98.1208 65.0500 98.7000)
  cqP("ETCH/TOP" "GND" 0.4000 82.3832 84.0000 82.1500 83.3000)
  cqP("ETCH/TOP" "GND" 0.4000 82.8832 91.9000 82.6500 91.2000)
  cqP("ETCH/TOP" "GND" 0.4000 133.8000 98.1000 133.5500 97.4000)
  cqP("ETCH/TOP" "GND" 0.4000 147.6668 65.9000 147.4000 65.2000)
  cqP("ETCH/TOP" "GND" 0.4000 157.6668 66.9500 157.4000 66.2500)
  cqP("ETCH/TOP" "GND" 0.4000 97.7540 106.7970 97.5000 106.1000)
  cqP("ETCH/TOP" "GND" 0.4000 114.8540 52.9980 114.6000 52.3000)
  cqP("ETCH/TOP" "GND" 0.4000 63.2030 55.6540 62.9500 54.9500)
  cqP("ETCH/TOP" "GND" 0.4000 53.4020 63.8540 53.1500 63.1500)
  cqP("ETCH/TOP" "GND" 0.4000 62.8540 106.5970 62.6000 105.9000)
  cqP("ETCH/TOP" "GND" 0.4000 127.4030 81.0540 127.1500 80.3500)
  cqP("ETCH/BOTTOM" "GND" 0.4000 85.8020 71.3792 85.4500 70.7000)
  cqP("ETCH/BOTTOM" "GND" 0.4000 90.1980 88.6208 90.7500 89.2000)
  cqP("ETCH/TOP" "GND" 0.4000 94.8208 86.7970 95.4000 87.3500)
  cqP("ETCH/TOP" "GND" 0.4000 94.8208 84.9980 95.4000 85.5500)
  cqP("ETCH/TOP" "GND" 0.4000 97.1208 103.2970 97.7000 103.8500)
  cqP("ETCH/TOP" "GND" 0.4000 96.0540 101.5970 95.8000 100.9000)
  cqP("ETCH/TOP" "GND" 0.4000 78.6530 90.2040 78.4000 89.5000)
  cqP("ETCH/TOP" "GND" 0.4000 78.6530 87.3540 78.4000 86.6500)
  cqP("ETCH/TOP" "GND" 0.4000 73.2030 63.5208 72.6500 64.1000)
  cqP("ETCH/TOP" "GND" 0.4000 56.9208 80.5970 57.5000 81.1500)
  cqP("ETCH/BOTTOM" "GND" 0.4000 85.4980 85.8208 86.2000 86.5500)
  cqP("ETCH/BOTTOM" "GND" 0.4000 88.8980 85.8208 88.5500 86.5000)
  cqP("ETCH/BOTTOM" "GND" 0.4000 93.8208 78.2030 93.5500 78.9000)
  cqP("ETCH/BOTTOM" "GND" 0.4000 96.6208 79.0020 97.2000 78.4500)
  cqP("ETCH/BOTTOM" "GND" 0.4000 90.5970 85.8208 91.1500 86.4000)
  cqP("ETCH/BOTTOM" "GND" 0.4000 95.8208 80.4030 95.4000 80.9500)
  cqP("ETCH/BOTTOM" "GND" 0.4000 90.6020 74.1792 89.8500 73.4000)
  cqP("ETCH/BOTTOM" "GND" 0.4000 88.8020 74.1792 88.2500 73.6000)
  cqP("ETCH/BOTTOM" "GND" 0.4000 85.4030 74.1792 84.5000 75.0500)
  cqP("ETCH/BOTTOM" "GND" 0.4000 82.1792 78.1980 82.2500 76.9000)
  cqP("ETCH/TOP" "GND" 0.4000 104.0540 84.8470 103.8000 84.1500)
  cqP("ETCH/TOP" "GND" 0.4000 56.9208 82.3980 57.6000 82.0500)
  cqP("ETCH/TOP" "GND" 0.4000 113.1208 62.3980 113.7000 62.9500)
  cqP("ETCH/TOP" "GND" 0.4000 60.9208 58.3980 61.5000 58.9500)
  cqP("ETCH/TOP" "GND" 0.4000 68.1208 64.5970 68.7000 65.1500)
  cqP("ETCH/TOP" "GND" 0.4000 109.4030 60.9208 108.8500 61.5000)
  cqP("ETCH/TOP" "GND" 0.4000 57.1208 62.3980 57.7000 62.9500)
  cqP("ETCH/TOP" "GND" 0.4000 70.8020 61.1208 70.2500 61.7000)
  cqP("ETCH/TOP" "GND" 0.4000 62.5208 102.7970 63.1000 103.3500)
  cqP("ETCH/TOP" "GND" 0.4000 118.1208 84.2480 118.7000 84.8000)
  cqP("ETCH/TOP" "GND" 0.4000 79.6020 104.7208 79.0500 105.3000)
  cqP("ETCH/TOP" "GND" 0.4000 95.5208 78.5470 96.2000 78.2000)
  cqP("ETCH/TOP" "GND" 0.4000 106.4530 60.9208 105.9000 61.5000)
  cqP("ETCH/BOTTOM" "GND" 0.4000 87.1020 74.1792 87.5000 73.3500)
  cqP("ETCH/BOTTOM" "GND" 0.4000 82.1792 80.9980 82.0000 83.1500)
  cqP("ETCH/TOP" "GND" 0.4000 60.7708 96.5470 61.3500 97.1000)
  cqP("ETCH/TOP" "GND" 0.4000 138.5668 91.0000 138.3000 90.3000)
  cqP("ETCH/TOP" "GND" 0.4000 148.5668 80.8000 148.3000 80.1000)
  cqP("ETCH/TOP" "GND" 0.4000 134.4668 63.6000 134.2000 62.9000)
  cqP("ETCH/TOP" "GND" 0.4000 144.8668 65.3700 144.6000 64.6500)
  cqP("ETCH/TOP" "GND" 0.4000 144.8668 71.5000 144.6000 70.8000)
  cqP("ETCH/TOP" "GND" 0.4000 144.8668 73.3000 144.6000 72.6000)
  cqP("ETCH/TOP" "GND" 0.4000 153.6668 68.9000 153.4000 68.2000)
  cqP("ETCH/TOP" "GND" 0.4000 147.0668 52.5000 146.8000 51.8000)
  cqP("ETCH/TOP" "GND" 0.4000 123.1500 79.4000 123.7000 78.7000)
  cqP("ETCH/TOP" "GND" 0.4000 102.4500 103.3000 103.0000 102.6000)
  cqP("ETCH/TOP" "GND" 0.4000 136.6378 64.0950 135.3500 64.6500)
  cqP("ETCH/TOP" "GND" 0.4000 141.2950 77.4150 140.8000 76.4500)
  cqP("ETCH/TOP" "GND" 0.4000 139.0050 77.4150 138.5000 76.4500)
  cqP("ETCH/TOP" "GND" 0.4000 143.5850 79.7050 143.1000 78.7500)
  cqP("ETCH/TOP" "GND" 0.4000 141.2950 79.7050 140.8000 78.7500)
  cqP("ETCH/TOP" "GND" 0.4000 139.0050 79.7050 138.5000 78.7500)
  cqP("ETCH/TOP" "GND" 0.4000 136.7150 79.7050 136.2000 78.7500)
  cqP("ETCH/TOP" "GND" 0.4000 141.2950 81.9950 140.8000 81.0500)
  cqP("ETCH/TOP" "GND" 0.4000 139.0050 81.9950 138.5000 81.0500)
  cqP("ETCH/TOP" "GND" 0.4000 136.7150 81.9950 136.2000 81.0500)
  cqP("ETCH/TOP" "GND" 0.4000 141.2950 84.2850 140.8000 83.3500)
  cqP("ETCH/TOP" "GND" 0.4000 139.0050 84.2850 138.5000 83.3500)
  cqP("ETCH/TOP" "GND" 0.4000 136.7150 84.2850 136.2000 83.3500)
  cqP("ETCH/TOP" "GND" 0.4000 134.4250 84.2850 133.6000 85.1000)
  cqP("ETCH/TOP" "GND" 0.4000 141.2950 86.5750 140.8000 85.6000)
  cqP("ETCH/TOP" "GND" 0.4000 139.0050 86.5750 138.5000 85.6000)
  cqP("ETCH/TOP" "GND" 0.4000 135.1020 91.0000 134.0500 89.9500)
  cqP("ETCH/TOP" "GND" 0.4000 135.1020 94.0000 134.0500 92.9500)
  cqP("ETCH/TOP" "GND" 0.4000 150.8020 86.5000 149.7500 85.4500)
  cqP("ETCH/TOP" "GND" 0.4000 150.8020 83.5000 149.7500 82.4500)
  cqP("ETCH/TOP" "GND" 0.4000 157.3020 59.5000 156.2500 58.4500)
  cqP("ETCH/TOP" "GND" 0.4000 157.3020 56.5000 156.2500 55.4500)
  cqP("ETCH/TOP" "GND" 0.4000 134.4224 67.3000 134.0500 66.4000)
  cqP("ETCH/TOP" "GND" 0.4000 145.2224 69.5000 144.8500 68.6000)
  cqP("ETCH/TOP" "GND" 0.4000 156.6224 71.0000 156.2500 70.1000)
  cqP("ETCH/TOP" "GND" 0.4000 151.8450 66.0000 150.7000 65.7500)
  cqP("ETCH/TOP" "GND" 0.4000 155.0750 51.9250 154.2500 51.3000)
  cqP("ETCH/TOP" "GND" 0.4000 150.9250 51.9250 150.1000 51.3000)
  cqP("ETCH/TOP" "5V" 0.5000 112.2000 60.1600 111.7500 60.7500)
  cqP("ETCH/TOP" "5V" 0.5000 66.9500 62.5600 66.5000 63.1500)
  cqP("ETCH/TOP" "5V" 0.5000 59.7500 62.5600 59.3000 63.1500)
  cqP("ETCH/TOP" "5V" 0.5000 61.9500 100.5600 61.5000 101.1500)
  cqP("ETCH/TOP" "5V" 0.5000 112.0540 62.3980 111.8000 61.7000)
  cqP("ETCH/TOP" "5V" 0.5000 67.0540 64.5970 66.8000 63.9000)
  cqP("ETCH/TOP" "5V" 0.5000 56.0540 62.3980 55.8000 61.7000)
  cqP("ETCH/TOP" "5V" 0.5000 61.4540 102.7970 61.2000 102.1000)
  cqP("ETCH/TOP" "5V" 0.5000 147.5000 80.8000 147.2500 80.1000)
  cqP("ETCH/TOP" "5V" 0.5000 143.5850 81.9950 143.1000 81.0500)
  cqP("ETCH/TOP" "5V" 0.5000 143.5850 84.2850 143.1000 83.3500)
  cqP("ETCH/TOP" "5V" 0.5000 143.5850 86.5750 144.4000 85.7500)
  cqP("ETCH/TOP" "5V" 0.5000 147.5000 86.5000 146.4500 85.4500)
  cqP("ETCH/TOP" "5V" 0.5000 147.5000 83.5000 146.4500 82.4500)
  cqP("ETCH/TOP" "5V" 0.5000 131.0000 70.5000 130.6000 69.6000)
  cqP("ETCH/TOP" "5V" 0.5000 152.0000 71.0000 151.6000 70.1000)
  cqP("ETCH/TOP" "N10087" 0.1500 91.4000 78.6000 92.7000 78.7500)
  cqP("ETCH/TOP" "N10087" 0.1500 92.7000 78.7500 94.8500 77.6500)
  cqP("ETCH/TOP" "N10087" 0.1500 94.8500 77.6500 95.4000 77.7500)
  cqP("ETCH/BOTTOM" "N10087" 0.1500 95.4000 77.7500 113.5000 60.9000)
  cqP("ETCH/TOP" "N10087" 0.1500 113.5000 60.9000 113.5000 60.1600)
  cqP("ETCH/TOP" "N10087" 0.2000 113.5000 60.1600 115.6020 60.8540)
  cqP("ETCH/TOP" "12V_RAW" 1.0000 147.6000 100.0000 142.3622 100.6350)
  cqP("ETCH/TOP" "12V_RAW" 1.0000 142.3622 100.6350 142.3622 101.9050)
  cqP("ETCH/TOP" "12V_RAW" 1.0000 142.3622 100.6350 142.3622 99.3650)
  cqP("ETCH/TOP" "12V_RAW" 1.0000 142.3622 99.3650 142.3622 98.0950)
  cqP("ETCH/TOP" "12V_IN" 1.0000 137.5000 91.0000 137.2000 90.7000)
  cqP("ETCH/TOP" "12V_IN" 1.0000 137.2000 90.7000 136.7150 86.5750)
  cqP("ETCH/TOP" "12V_IN" 1.0000 136.7150 86.5750 134.4250 86.5750)
  cqP("ETCH/TOP" "12V_IN" 1.0000 134.4250 86.5750 131.8000 91.0000)
  cqP("ETCH/TOP" "12V_IN" 1.0000 131.8000 91.0000 131.8000 94.0000)
  cqP("ETCH/TOP" "12V_IN" 1.0000 131.8000 94.0000 136.0000 97.7000)
  cqP("ETCH/TOP" "12V_IN" 1.0000 136.0000 97.7000 136.0000 98.6500)
  cqP("ETCH/TOP" "12V_IN" 1.0000 136.0000 98.6500 136.4000 99.1000)
  cqP("ETCH/TOP" "12V_IN" 1.0000 136.4000 99.1000 137.6378 99.3650)
  cqP("ETCH/TOP" "12V_IN" 1.0000 137.6378 99.3650 137.6378 100.6350)
  cqP("ETCH/TOP" "12V_IN" 1.0000 137.6378 100.6350 137.6378 101.9050)
  cqP("ETCH/TOP" "12V_IN" 1.0000 137.6378 101.9050 133.5000 102.2500)
  cqP("ETCH/TOP" "12V_IN" 1.0000 133.5000 102.2500 131.5000 103.5000)
  cqP("ETCH/TOP" "N327857" 0.5000 151.8450 65.0500 148.0000 62.0000)
  cqP("ETCH/TOP" "1V2_REG" 0.5000 156.6000 65.0000 151.4290 62.0000)
  cqP("ETCH/TOP" "1V2_REG" 0.5000 151.4290 62.0000 154.0000 59.5000)
  cqP("ETCH/TOP" "1V2_REG" 0.5000 154.0000 59.5000 154.0000 56.5000)
  cqP("ETCH/TOP" "1V2_REG" 0.5000 151.4290 62.0000 148.4500 60.0000)
  cqP("ETCH/TOP" "1V2_REG" 0.5000 148.4500 60.0000 147.7000 59.9000)
  cqP("ETCH/TOP" "1V2_REG" 0.5000 147.7000 59.9000 147.3500 59.3500)
  cqP("ETCH/TOP" "1V2_REG" 0.5000 147.3500 59.3500 147.0000 58.5000)
  cqP("ETCH/TOP" "5V_REG_1V2" 0.5000 152.6000 68.9000 151.8450 66.9500)
  cqP("ETCH/TOP" "5V_REG_1V2" 0.5000 152.6000 68.9000 153.4224 71.0000)
  cqP("ETCH/TOP" "5V_REG_1V2" 0.5000 153.4224 71.0000 155.2000 71.0000)
  cqP("ETCH/TOP" "5V_REG_1V2" 0.5000 151.8450 66.9500 152.8500 66.6500)
  cqP("ETCH/TOP" "5V_REG_1V2" 0.5000 152.8500 66.6500 153.0000 66.5000)
  cqP("ETCH/TOP" "5V_REG_1V2" 0.5000 153.0000 66.5000 153.0500 65.4500)
  cqP("ETCH/TOP" "5V_REG_1V2" 0.5000 153.0500 65.4500 153.2000 65.3000)
  cqP("ETCH/TOP" "5V_REG_1V2" 0.5000 153.2000 65.3000 154.1550 65.0500)
  cqP("ETCH/TOP" "5V_REG_3V3" 0.5000 130.6000 65.4000 131.9000 66.8500)
  cqP("ETCH/TOP" "5V_REG_3V3" 0.5000 131.9000 66.8500 133.0000 67.3000)
  cqP("ETCH/TOP" "5V_REG_3V3" 0.5000 133.0000 67.3000 132.4224 70.5000)
  cqP("ETCH/TOP" "5V_REG_3V3" 0.5000 133.0000 67.3000 133.8500 68.2000)
  cqP("ETCH/TOP" "5V_REG_3V3" 0.5000 133.8500 68.2000 135.6500 68.1500)
  cqP("ETCH/TOP" "5V_REG_3V3" 0.5000 135.6500 68.1500 136.6378 67.9050)
  cqP("ETCH/TOP" "5V_REG_3V3" 0.5000 136.6378 67.9050 136.6378 66.6350)
  cqP("ETCH/TOP" "PWR1" 0.4000 57.5200 87.7250 58.7300 87.7500)
  cqP("ETCH/BOTTOM" "PWR1" 0.4000 57.5200 87.7250 58.3000 88.3500)
  cqP("ETCH/BOTTOM" "PWR1" 0.4000 58.3000 88.3500 59.6000 90.1000)
  cqP("ETCH/TOP" "PWR1" 0.4000 59.6000 90.1000 59.4500 90.2500)
  cqP("ETCH/TOP" "PWR1" 0.4000 59.4500 90.2500 58.7300 90.2500)
  cqP("ETCH/BOTTOM" "PWR1" 0.6000 58.8500 89.1000 57.9000 90.2000)
  cqP("ETCH/BOTTOM" "PWR1" 0.6000 57.9000 90.2000 57.5200 90.2750)
  cqP("ETCH/TOP" "PWR1" 0.6000 59.6000 90.1000 62.3000 90.9000)
  cqP("ETCH/TOP" "PWR1" 0.6000 62.3000 90.9000 62.8208 91.5970)
  cqP("ETCH/TOP" "PWR1" 0.6000 62.8208 91.5970 64.4000 90.8500)
  cqP("ETCH/TOP" "PWR1" 0.6000 64.4000 90.8500 65.4000 90.9000)
  cqP("ETCH/TOP" "PWR1" 0.6000 65.4000 90.9000 65.9208 91.5970)
  cqP("ETCH/TOP" "PWR1" 0.6000 62.8208 91.5970 59.7040 96.5470)
  cqP("ETCH/TOP" "PWR1" 0.6000 59.7040 96.5470 60.1000 97.1500)
  cqP("ETCH/TOP" "PWR1" 0.6000 60.1000 97.1500 61.9500 98.6400)
  cqP("ETCH/TOP" "PWR1" 0.6000 59.7040 96.5470 54.3300 100.8000)
  cqP("ETCH/TOP" "PWR1" 0.6000 54.3300 100.8000 59.4540 106.5970)
  cqP("ETCH/TOP" "PWR2" 0.4000 57.5200 69.7250 58.7300 69.7500)
  cqP("ETCH/BOTTOM" "PWR2" 0.4000 57.5200 69.7250 58.3000 70.3500)
  cqP("ETCH/BOTTOM" "PWR2" 0.4000 58.3000 70.3500 59.6000 72.1000)
  cqP("ETCH/TOP" "PWR2" 0.4000 59.6000 72.1000 59.4500 72.2500)
  cqP("ETCH/TOP" "PWR2" 0.4000 59.4500 72.2500 58.7300 72.2500)
  cqP("ETCH/BOTTOM" "PWR2" 0.6000 58.8500 71.1000 57.9000 72.2000)
  cqP("ETCH/BOTTOM" "PWR2" 0.6000 57.9000 72.2000 57.5200 72.2750)
  cqP("ETCH/BOTTOM" "PWR2" 0.6000 59.6000 72.1000 60.0500 74.4000)
  cqP("ETCH/BOTTOM" "PWR2" 0.6000 60.0500 74.4000 59.9000 74.8000)
  cqP("ETCH/BOTTOM" "PWR2" 0.6000 59.9000 74.8000 57.2000 77.9000)
  cqP("ETCH/TOP" "PWR2" 0.6000 57.2000 77.9000 56.9208 78.5970)
  cqP("ETCH/TOP" "PWR2" 0.6000 56.9208 78.5970 56.3000 77.8500)
  cqP("ETCH/TOP" "PWR2" 0.6000 56.3000 77.8500 55.3000 77.9000)
  cqP("ETCH/TOP" "PWR2" 0.6000 55.3000 77.9000 53.7208 78.5970)
  cqP("ETCH/BOTTOM" "PWR2" 0.6000 57.5200 69.7250 59.9000 68.1500)
  cqP("ETCH/BOTTOM" "PWR2" 0.6000 59.9000 68.1500 60.0500 67.6000)
  cqP("ETCH/BOTTOM" "PWR2" 0.6000 60.0500 67.6000 58.5000 63.2500)
  cqP("ETCH/BOTTOM" "PWR2" 0.6000 58.5000 63.2500 59.1500 61.0000)
  cqP("ETCH/TOP" "PWR2" 0.6000 59.1500 61.0000 59.4000 60.7000)
  cqP("ETCH/TOP" "PWR2" 0.6000 59.4000 60.7000 59.7500 60.6400)
  cqP("ETCH/TOP" "PWR2" 0.6000 59.7500 60.6400 59.8540 58.3980)
  cqP("ETCH/BOTTOM" "PWR2" 0.6000 59.1000 61.1000 55.9000 60.9000)
  cqP("ETCH/BOTTOM" "PWR2" 0.6000 55.9000 60.9000 54.1000 60.9000)
  cqP("ETCH/TOP" "PWR2" 0.6000 54.1000 60.9000 53.4020 60.8540)
  cqP("ETCH/TOP" "PWR2" 0.6000 53.4020 60.8540 53.9300 55.4000)
  cqP("ETCH/TOP" "PWR4" 0.4000 98.2750 57.5200 98.2500 58.7300)
  cqP("ETCH/BOTTOM" "PWR4" 0.4000 98.2750 57.5200 97.6500 58.3000)
  cqP("ETCH/BOTTOM" "PWR4" 0.4000 97.6500 58.3000 95.9000 59.6000)
  cqP("ETCH/TOP" "PWR4" 0.4000 95.9000 59.6000 95.7500 59.4500)
  cqP("ETCH/TOP" "PWR4" 0.4000 95.7500 59.4500 95.7500 58.7300)
  cqP("ETCH/BOTTOM" "PWR4" 0.6000 96.9000 58.8500 95.8000 57.9000)
  cqP("ETCH/BOTTOM" "PWR4" 0.6000 95.8000 57.9000 95.7250 57.5200)
  cqP("ETCH/BOTTOM" "PWR4" 0.6000 98.2750 57.5200 99.8500 59.9000)
  cqP("ETCH/BOTTOM" "PWR4" 0.6000 99.8500 59.9000 100.4000 60.0500)
  cqP("ETCH/BOTTOM" "PWR4" 0.6000 100.4000 60.0500 100.8000 59.9000)
  cqP("ETCH/BOTTOM" "PWR4" 0.6000 100.8000 59.9000 106.3300 55.0000)
  cqP("ETCH/TOP" "PWR4" 0.6000 106.3300 55.0000 109.4030 59.8540)
  cqP("ETCH/TOP" "PWR4" 0.6000 109.4030 59.8540 110.9500 58.3000)
  cqP("ETCH/TOP" "PWR4" 0.6000 110.9500 58.3000 112.2000 58.2400)
  cqP("ETCH/TOP" "PWR4" 0.6000 109.4030 59.8540 108.8000 60.2500)
  cqP("ETCH/TOP" "PWR4" 0.6000 108.8000 60.2500 106.9500 62.1500)
  cqP("ETCH/TOP" "PWR4" 0.6000 106.9500 62.1500 107.0000 63.1500)
  cqP("ETCH/TOP" "PWR4" 0.6000 107.0000 63.1500 107.7000 63.6668)
  cqP("ETCH/TOP" "PWR4" 0.6000 107.0000 63.1500 106.0000 63.6668)
  cqP("ETCH/TOP" "PWR4" 0.6000 112.2000 58.2400 111.9040 52.9980)
  cqP("ETCH/TOP" "UP_VBUS" 0.4000 87.7250 102.4800 87.7500 101.2700)
  cqP("ETCH/BOTTOM" "UP_VBUS" 0.4000 87.7250 102.4800 88.3500 101.7000)
  cqP("ETCH/BOTTOM" "UP_VBUS" 0.4000 88.3500 101.7000 90.1000 100.4000)
  cqP("ETCH/TOP" "UP_VBUS" 0.4000 90.1000 100.4000 90.2500 100.5500)
  cqP("ETCH/TOP" "UP_VBUS" 0.4000 90.2500 100.5500 90.2500 101.2700)
  cqP("ETCH/TOP" "UP_VBUS" 0.4000 90.2500 101.2700 90.2750 102.4800)
  cqP("ETCH/TOP" "UP_VBUS" 0.4000 90.2500 100.5500 92.3500 100.0500)
  cqP("ETCH/TOP" "UP_VBUS" 0.4000 92.3500 100.0500 92.7500 100.2000)
  cqP("ETCH/TOP" "UP_VBUS" 0.4000 92.7500 100.2000 96.0540 103.2970)
  cqP("ETCH/TOP" "UP_VBUS" 0.4000 96.0540 103.2970 97.1208 101.5970)
  cqP("ETCH/TOP" "UP_VBUS" 0.4000 92.7000 100.1500 94.5500 98.2500)
  cqP("ETCH/TOP" "UP_VBUS" 0.4000 94.5500 98.2500 94.6000 87.5500)
  cqP("ETCH/BOTTOM" "UP_VBUS" 0.4000 94.6000 87.5500 94.8000 82.8000)
  cqP("ETCH/TOP" "UP_VBUS" 0.4000 94.8000 82.8000 94.4540 82.1980)
  cqP("ETCH/TOP" "N30602" 0.2000 103.8540 107.5970 102.1208 107.5970)
  cqP("ETCH/TOP" "N35147" 0.2000 110.7235 79.9650 108.9208 79.3980)
  cqP("ETCH/TOP" "N37438" 0.2000 125.4030 82.1208 127.4030 82.1208)
  cqP("ETCH/TOP" "N37434" 0.2000 125.4030 81.0540 123.1500 81.8000)
  cqP("ETCH/TOP" "N328021" 0.2000 143.8000 65.3700 141.3622 65.3650)
  cqP("ETCH/TOP" "N3269173" 0.2000 134.8668 98.1000 135.0500 98.8000)
  cqP("ETCH/BOTTOM" "N3269173" 0.2000 135.0500 98.8000 136.9500 97.4000)
  cqP("ETCH/TOP" "N3269173" 0.2000 136.9500 97.4000 137.6378 98.0950)
  cqP("ETCH/TOP" "N10037" 0.2000 112.8500 58.2400 113.2500 57.6500)
  cqP("ETCH/TOP" "N10037" 0.2000 113.2500 57.6500 115.6020 57.8540)
  cqP("ETCH/TOP" "N35181" 0.2000 115.6765 81.2350 117.1000 81.0500)
  cqP("ETCH/TOP" "N35181" 0.2000 117.1000 81.0500 117.9500 81.0500)
  cqP("ETCH/TOP" "N35181" 0.2000 117.9500 81.0500 118.5708 81.5970)
  cqP("ETCH/TOP" "N15441" 0.2000 112.9708 52.9980 114.3500 53.5500)
  cqP("ETCH/TOP" "N15441" 0.2000 114.3500 53.5500 115.3500 53.5000)
  cqP("ETCH/TOP" "N15441" 0.2000 115.3500 53.5000 115.9208 52.9980)
  cqP("ETCH/TOP" "N15563" 0.2000 53.4020 61.9208 53.9500 63.4500)
  cqP("ETCH/TOP" "N15563" 0.2000 53.9500 63.4500 53.9000 64.3500)
  cqP("ETCH/TOP" "N15563" 0.2000 53.9000 64.3500 53.4020 64.9208)
  cqP("ETCH/TOP" "N10536" 0.2000 60.4000 60.6400 60.8000 60.0500)
  cqP("ETCH/TOP" "N10536" 0.2000 60.8000 60.0500 63.4020 59.8540)
  cqP("ETCH/TOP" "N15499" 0.2000 63.2030 53.5208 63.7500 55.2500)
  cqP("ETCH/TOP" "N15499" 0.2000 63.7500 55.2500 63.7500 56.1000)
  cqP("ETCH/TOP" "N15499" 0.2000 63.7500 56.1000 63.2030 56.7208)
  cqP("ETCH/TOP" "N06818" 0.2000 62.6000 98.6400 62.8500 98.1500)
  cqP("ETCH/TOP" "N06818" 0.2000 62.8500 98.1500 65.6020 97.0540)
  cqP("ETCH/TOP" "N15627" 0.2000 60.5208 106.5970 62.4500 107.1500)
  cqP("ETCH/TOP" "N15627" 0.2000 62.4500 107.1500 63.3500 107.1000)
  cqP("ETCH/TOP" "N15627" 0.2000 63.3500 107.1000 63.9208 106.5970)
  cqP("ETCH/TOP" "N10630" 0.2000 61.0500 60.6400 62.2000 62.1000)
  cqP("ETCH/BOTTOM" "N10630" 0.2000 62.2000 62.1000 62.7500 63.4500)
  cqP("ETCH/TOP" "N10630" 0.2000 62.7500 63.4500 63.4020 63.9208)
  cqP("ETCH/TOP" "N10131" 0.2000 113.5000 58.2400 114.4500 59.2000)
  cqP("ETCH/TOP" "N10131" 0.2000 114.4500 59.2000 114.5500 59.8500)
  cqP("ETCH/TOP" "N10131" 0.2000 114.5500 59.8500 115.1000 60.3000)
  cqP("ETCH/TOP" "N10131" 0.2000 115.1000 60.3000 116.1000 60.3500)
  cqP("ETCH/TOP" "N10131" 0.2000 116.1000 60.3500 116.1500 61.2500)
  cqP("ETCH/TOP" "N10131" 0.2000 116.1500 61.2500 115.6020 61.9208)
  cqP("ETCH/BOTTOM" "DN3_CC2" 0.2000 78.1250 56.8200 77.5000 56.2500)
  cqP("ETCH/BOTTOM" "DN3_CC2" 0.2000 77.5000 56.2500 74.6000 55.9000)
  cqP("ETCH/BOTTOM" "DN3_CC2" 0.2000 74.6000 55.9000 74.1500 56.2500)
  cqP("ETCH/BOTTOM" "DN3_CC2" 0.2000 74.1500 56.2500 74.0500 57.3000)
  cqP("ETCH/BOTTOM" "DN3_CC2" 0.2000 74.0500 57.3000 75.2000 59.6000)
  cqP("ETCH/BOTTOM" "DN3_CC2" 0.2000 75.2000 59.6000 76.5500 60.7500)
  cqP("ETCH/TOP" "DN3_CC2" 0.2000 76.5500 60.7500 77.2520 61.0540)
  cqP("ETCH/TOP" "N09647" 0.2000 68.2500 60.6400 70.3000 62.7000)
  cqP("ETCH/TOP" "N09647" 0.2000 70.3000 62.7000 71.3000 62.7500)
  cqP("ETCH/TOP" "N09647" 0.2000 71.3000 62.7500 72.0000 63.5000)
  cqP("ETCH/TOP" "N09647" 0.2000 72.0000 63.5000 72.0000 64.0000)
  cqP("ETCH/TOP" "N09647" 0.2000 72.0000 64.0000 71.7000 64.3000)
  cqP("ETCH/TOP" "N09647" 0.2000 71.7000 64.3000 70.8020 64.3208)
  cqP("ETCH/TOP" "DN1_CC1" 0.2000 58.7300 88.2500 59.6000 88.3500)
  cqP("ETCH/BOTTOM" "DN1_CC1" 0.2000 59.6000 88.3500 61.0500 91.3500)
  cqP("ETCH/TOP" "DN1_CC1" 0.2000 61.0500 91.3500 61.7540 91.5970)
  cqP("ETCH/TOP" "N327891" 0.2000 156.6000 66.9500 156.9000 65.9000)
  cqP("ETCH/TOP" "N327891" 0.2000 156.9000 65.9000 157.6668 65.0000)
  cqP("ETCH/TOP" "N327891" 0.2000 156.6000 66.9500 154.1550 66.9500)
  cqP("ETCH/TOP" "DN3_CC1" 0.2000 79.7500 58.7300 79.6500 59.6000)
  cqP("ETCH/BOTTOM" "DN3_CC1" 0.2000 79.6500 59.6000 77.6500 60.2500)
  cqP("ETCH/BOTTOM" "DN3_CC1" 0.2000 77.6500 60.2500 77.0500 60.1500)
  cqP("ETCH/TOP" "DN3_CC1" 0.2000 77.0500 60.1500 76.2000 60.2500)
  cqP("ETCH/TOP" "DN3_CC1" 0.2000 76.2000 60.2500 75.4030 61.0540)
  cqP("ETCH/TOP" "N30304" 0.2000 100.9540 100.9980 100.0000 102.7500)
  cqP("ETCH/TOP" "N30304" 0.2000 100.0000 102.7500 100.0000 103.8500)
  cqP("ETCH/TOP" "N30304" 0.2000 100.0000 103.8500 102.4500 105.7000)
  cqP("ETCH/TOP" "N34960" 0.2000 104.6702 81.5754 105.6500 81.8000)
  cqP("ETCH/TOP" "N34960" 0.2000 105.6500 81.8000 106.1500 82.3000)
  cqP("ETCH/TOP" "N34960" 0.2000 106.1500 82.3000 106.1500 83.6000)
  cqP("ETCH/BOTTOM" "N34960" 0.2000 106.1500 83.6000 106.1500 86.0000)
  cqP("ETCH/TOP" "N34960" 0.2000 106.1500 86.0000 106.4208 86.6980)
  cqP("ETCH/TOP" "UP_CC1" 0.2000 88.2500 101.2700 88.3000 100.4000)
  cqP("ETCH/BOTTOM" "UP_CC1" 0.2000 88.3000 100.4000 91.5500 97.6500)
  cqP("ETCH/TOP" "UP_CC1" 0.2000 91.5500 97.6500 92.2540 97.3980)
  cqP("ETCH/TOP" "N33797" 0.2000 110.7235 81.2350 109.4500 80.9500)
  cqP("ETCH/TOP" "N33797" 0.2000 109.4500 80.9500 108.5000 80.9500)
  cqP("ETCH/TOP" "N33797" 0.2000 108.5000 80.9500 107.8540 81.4980)
  cqP("ETCH/TOP" "N33797" 0.2000 107.8540 81.4980 108.0000 80.8000)
  cqP("ETCH/BOTTOM" "N33797" 0.2000 108.0000 80.8000 105.9500 79.7500)
  cqP("ETCH/TOP" "N33797" 0.2000 105.9500 79.7500 104.6702 79.6246)
  cqP("ETCH/BOTTOM" "DN2_CC2" 0.2000 56.8200 71.8750 56.1000 72.5500)
  cqP("ETCH/BOTTOM" "DN2_CC2" 0.2000 56.1000 72.5500 55.1500 78.8000)
  cqP("ETCH/TOP" "DN2_CC2" 0.2000 55.1500 78.8000 55.8540 78.5970)
  cqP("ETCH/TOP" "N328103" 0.2000 147.6668 67.6000 146.6000 65.9000)
  cqP("ETCH/TOP" "N328103" 0.2000 146.9500 66.5000 146.8500 66.6000)
  cqP("ETCH/BOTTOM" "N328103" 0.2000 146.8500 66.6000 142.8000 66.6000)
  cqP("ETCH/TOP" "N328103" 0.2000 142.8000 66.6000 141.3622 66.6350)
  cqP("ETCH/TOP" "UP_CC2" 0.2000 89.8750 103.1800 90.5000 103.7500)
  cqP("ETCH/TOP" "UP_CC2" 0.2000 90.5000 103.7500 92.5500 104.1500)
  cqP("ETCH/BOTTOM" "UP_CC2" 0.2000 92.5500 104.1500 93.5500 104.0500)
  cqP("ETCH/BOTTOM" "UP_CC2" 0.2000 93.5500 104.0500 93.9000 103.6500)
  cqP("ETCH/BOTTOM" "UP_CC2" 0.2000 93.9000 103.6500 93.9000 102.5000)
  cqP("ETCH/BOTTOM" "UP_CC2" 0.2000 93.9000 102.5000 92.5000 96.4000)
  cqP("ETCH/TOP" "UP_CC2" 0.2000 92.5000 96.4000 92.2540 95.6980)
  cqP("ETCH/BOTTOM" "DN1_CC2" 0.2000 56.8200 89.8750 56.2500 90.5000)
  cqP("ETCH/BOTTOM" "DN1_CC2" 0.2000 56.2500 90.5000 55.9000 93.4000)
  cqP("ETCH/BOTTOM" "DN1_CC2" 0.2000 55.9000 93.4000 56.2500 93.8500)
  cqP("ETCH/BOTTOM" "DN1_CC2" 0.2000 56.2500 93.8500 57.7500 94.1000)
  cqP("ETCH/BOTTOM" "DN1_CC2" 0.2000 57.7500 94.1000 62.7500 94.2000)
  cqP("ETCH/BOTTOM" "DN1_CC2" 0.2000 62.7500 94.2000 64.5500 92.3000)
  cqP("ETCH/TOP" "DN1_CC2" 0.2000 64.5500 92.3000 64.8540 91.5970)
  cqP("ETCH/TOP" "N30428" 0.2000 102.0208 100.9980 101.0500 102.2000)
  cqP("ETCH/BOTTOM" "N30428" 0.2000 101.0500 102.2000 99.1000 106.1000)
  cqP("ETCH/TOP" "N30428" 0.2000 99.1000 106.1000 98.8208 106.7970)
  cqP("ETCH/TOP" "N30428" 0.2000 98.8208 106.7970 101.0540 107.5970)
  cqP("ETCH/TOP" "DN4_CC1" 0.2000 97.7500 58.7300 97.8500 59.3500)
  cqP("ETCH/TOP" "DN4_CC1" 0.2000 97.8500 59.3500 98.2500 59.7500)
  cqP("ETCH/BOTTOM" "DN4_CC1" 0.2000 98.2500 59.7500 100.8500 62.3500)
  cqP("ETCH/BOTTOM" "DN4_CC1" 0.2000 100.8500 62.3500 105.3000 62.3500)
  cqP("ETCH/TOP" "DN4_CC1" 0.2000 105.3000 62.3500 106.0000 62.6000)
  cqP("ETCH/TOP" "DN2_CC1" 0.2000 58.7300 70.2500 59.6000 70.3500)
  cqP("ETCH/BOTTOM" "DN2_CC1" 0.2000 59.6000 70.3500 60.2500 71.7000)
  cqP("ETCH/TOP" "DN2_CC1" 0.2000 60.2500 71.7000 59.7500 74.6500)
  cqP("ETCH/TOP" "DN2_CC1" 0.2000 59.7500 74.6500 52.9000 78.3500)
  cqP("ETCH/TOP" "DN2_CC1" 0.2000 52.9000 78.3500 52.6540 78.5970)
  cqP("ETCH/TOP" "N42024" 0.2000 104.6702 78.9744 106.3000 79.2500)
  cqP("ETCH/TOP" "N42024" 0.2000 106.3000 79.2500 106.8500 80.2000)
  cqP("ETCH/TOP" "N42024" 0.2000 106.8500 80.2000 106.7500 80.8000)
  cqP("ETCH/TOP" "N42024" 0.2000 106.7500 80.8000 106.7500 82.2000)
  cqP("ETCH/TOP" "N42024" 0.2000 106.7500 82.2000 106.9500 83.1500)
  cqP("ETCH/BOTTOM" "N42024" 0.2000 106.9500 83.1500 110.1000 86.5500)
  cqP("ETCH/TOP" "N42024" 0.2000 110.1000 86.5500 110.8400 87.3168)
  cqP("ETCH/TOP" "N32206" 0.2000 105.2540 102.5970 105.9000 103.1500)
  cqP("ETCH/TOP" "N32206" 0.2000 105.9000 103.1500 108.5500 103.0500)
  cqP("ETCH/TOP" "N32206" 0.2000 108.5500 103.0500 109.3000 102.6500)
  cqP("ETCH/TOP" "N32206" 0.2000 109.3000 102.6500 112.6500 102.6500)
  cqP("ETCH/BOTTOM" "N32206" 0.2000 112.6500 102.6500 113.6500 102.0000)
  cqP("ETCH/BOTTOM" "N32206" 0.2000 113.6500 102.0000 114.5000 102.0500)
  cqP("ETCH/BOTTOM" "N32206" 0.2000 114.5000 102.0500 118.0000 103.2000)
  cqP("ETCH/BOTTOM" "DN4_CC2" 0.2000 96.1250 56.8200 98.4000 55.4000)
  cqP("ETCH/TOP" "DN4_CC2" 0.2000 98.4000 55.4000 99.4500 54.5000)
  cqP("ETCH/TOP" "DN4_CC2" 0.2000 99.4500 54.5000 102.3500 54.5500)
  cqP("ETCH/TOP" "DN4_CC2" 0.2000 102.3500 54.5500 107.5500 59.7500)
  cqP("ETCH/TOP" "DN4_CC2" 0.2000 107.5500 59.7500 107.5500 60.4000)
  cqP("ETCH/BOTTOM" "DN4_CC2" 0.2000 107.5500 60.4000 108.2000 61.9500)
  cqP("ETCH/TOP" "DN4_CC2" 0.2000 108.2000 61.9500 107.7000 62.6000)
  cqP("ETCH/TOP" "N33785" 0.2000 115.6765 78.6950 111.5000 78.1000)
  cqP("ETCH/TOP" "N33785" 0.2000 111.5000 78.1000 109.9500 78.1000)
  cqP("ETCH/TOP" "N33785" 0.2000 109.9500 78.1000 106.9000 79.1000)
  cqP("ETCH/BOTTOM" "N33785" 0.2000 106.9000 79.1000 105.6000 79.2500)
  cqP("ETCH/BOTTOM" "N33785" 0.2000 105.6000 79.2500 97.6500 81.3000)
  cqP("ETCH/TOP" "N33785" 0.2000 97.6500 81.3000 97.8500 80.6000)
  cqP("ETCH/TOP" "N33785" 0.2000 97.8500 80.6000 98.1500 80.4000)
  cqP("ETCH/TOP" "N33785" 0.2000 98.1500 80.4000 98.9298 80.2749)
  cqP("ETCH/TOP" "N34925" 0.2000 110.7235 82.5050 111.8000 82.6500)
  cqP("ETCH/BOTTOM" "N34925" 0.2000 111.8000 82.6500 109.6000 84.0000)
  cqP("ETCH/TOP" "N34925" 0.2000 109.6000 84.0000 108.9208 83.5970)
  cqP("ETCH/TOP" "N34925" 0.2000 108.9208 83.5970 106.7000 85.4000)
  cqP("ETCH/TOP" "N34925" 0.2000 106.7000 85.4000 105.8000 85.5000)
  cqP("ETCH/TOP" "N34925" 0.2000 105.8000 85.5000 105.5500 85.9500)
  cqP("ETCH/TOP" "N34925" 0.2000 105.5500 85.9500 105.3540 86.6980)
  cqP("ETCH/TOP" "N34925" 0.2000 111.8000 82.6500 114.6500 80.5500)
  cqP("ETCH/TOP" "N34925" 0.2000 114.6500 80.5500 119.4000 80.5000)
  cqP("ETCH/TOP" "N34925" 0.2000 119.4000 80.5000 121.7000 80.0500)
  cqP("ETCH/TOP" "N34925" 0.2000 121.7000 80.0500 122.2000 79.4000)
  cqP("ETCH/TOP" "N26306" 0.2000 115.6765 79.9650 117.5040 79.3980)
  cqP("ETCH/TOP" "N26306" 0.2000 115.6765 79.9650 114.4500 80.2000)
  cqP("ETCH/TOP" "N26306" 0.2000 114.4500 80.2000 111.9500 81.8500)
  cqP("ETCH/BOTTOM" "N26306" 0.2000 111.9500 81.8500 109.4500 82.6500)
  cqP("ETCH/BOTTOM" "N26306" 0.2000 109.4500 82.6500 104.0000 82.3500)
  cqP("ETCH/BOTTOM" "N26306" 0.2000 104.0000 82.3500 103.4500 82.7000)
  cqP("ETCH/BOTTOM" "N26306" 0.2000 103.4500 82.7000 97.7000 82.4500)
  cqP("ETCH/TOP" "N26306" 0.2000 97.7000 82.4500 98.9298 82.2256)
  cqP("ETCH/TOP" "N41897" 0.2000 104.6702 80.9251 105.6500 81.1500)
  cqP("ETCH/TOP" "N41897" 0.2000 105.6500 81.1500 106.1500 81.5000)
  cqP("ETCH/BOTTOM" "N41897" 0.2000 106.1500 81.5000 112.2000 81.3000)
  cqP("ETCH/BOTTOM" "N41897" 0.2000 112.2000 81.3000 120.2000 91.7500)
  cqP("ETCH/BOTTOM" "N41897" 0.2000 120.2000 91.7500 120.2500 93.3000)
  cqP("ETCH/TOP" "N41897" 0.2000 120.2500 93.3000 121.0000 94.0668)
  cqP("ETCH/TOP" "EN3" 0.2000 131.6668 65.4000 133.4000 63.6000)
  cqP("ETCH/TOP" "EN3" 0.2000 133.4000 63.6000 135.1000 65.2000)
  cqP("ETCH/TOP" "EN3" 0.2000 135.1000 65.2000 136.6378 65.3650)
  cqP("ETCH/TOP" "EN3" 0.2000 136.6378 65.3650 139.8500 65.7500)
  cqP("ETCH/BOTTOM" "EN3" 0.2000 139.8500 65.7500 149.9000 65.8000)
  cqP("ETCH/BOTTOM" "EN3" 0.2000 149.9000 65.8000 150.4500 66.3000)
  cqP("ETCH/BOTTOM" "EN3" 0.2000 150.4500 66.3000 155.3000 66.2500)
  cqP("ETCH/TOP" "EN3" 0.2000 155.3000 66.2500 154.1550 66.0000)
  cqP("ETCH/TOP" "N30235" 0.1500 98.9298 82.8758 97.2500 83.0000)
  cqP("ETCH/TOP" "N30235" 0.1500 97.2500 83.0000 97.0000 82.7500)
  cqP("ETCH/BOTTOM" "N30235" 0.1500 97.0000 82.7500 101.8000 102.4500)
  cqP("ETCH/TOP" "N30235" 0.1500 101.8000 102.4500 101.5000 103.3000)
  cqP("ETCH/TOP" "N30235" 0.2000 101.8000 102.4500 103.0500 102.0000)
  cqP("ETCH/TOP" "N30235" 0.2000 103.0500 102.0000 105.7000 102.0500)
  cqP("ETCH/TOP" "N30235" 0.2000 105.7000 102.0500 106.3208 102.5970)
  cqP("ETCH/TOP" "3V3" 0.4000 115.6765 82.5050 117.5040 81.5970)
  cqP("ETCH/TOP" "3V3" 0.4000 115.6765 82.5050 117.0540 84.2480)
  cqP("ETCH/TOP" "3V3" 0.4000 117.5040 81.5970 118.1500 82.2500)
  cqP("ETCH/TOP" "3V3" 0.4000 118.1500 82.2500 121.0000 82.2000)
  cqP("ETCH/TOP" "3V3" 0.4000 121.0000 82.2000 121.2500 81.8000)
  cqP("ETCH/TOP" "3V3" 0.4000 115.6765 82.5050 114.5000 83.3500)
  cqP("ETCH/TOP" "3V3" 0.4000 114.5000 83.3500 109.8000 83.3500)
  cqP("ETCH/TOP" "3V3" 0.4000 109.8000 83.3500 109.3500 82.9500)
  cqP("ETCH/TOP" "3V3" 0.4000 109.3500 82.9500 108.4000 83.0000)
  cqP("ETCH/TOP" "3V3" 0.4000 108.4000 83.0000 107.8540 83.5970)
  cqP("ETCH/TOP" "3V3" 0.4000 107.8540 83.5970 105.1208 84.8470)
  cqP("ETCH/TOP" "3V3" 0.4000 105.1208 84.8470 104.6702 82.8758)
  cqP("ETCH/TOP" "3V3" 0.4000 107.8540 83.5970 107.2000 81.9500)
  cqP("ETCH/TOP" "3V3" 0.4000 107.2000 81.9500 107.2000 81.0500)
  cqP("ETCH/TOP" "3V3" 0.4000 107.2000 81.0500 107.8540 79.3980)
  cqP("ETCH/TOP" "3V3" 0.4000 117.0540 84.2480 114.0000 103.2000)
  cqP("ETCH/TOP" "3V3" 0.4000 114.0000 103.2000 109.7500 107.3500)
  cqP("ETCH/TOP" "3V3" 0.4000 109.7500 107.3500 104.9208 107.5970)
  cqP("ETCH/TOP" "3V3" 0.4000 104.9208 107.5970 103.7500 106.3500)
  cqP("ETCH/TOP" "3V3" 0.4000 103.7500 106.3500 103.1000 106.4500)
  cqP("ETCH/TOP" "3V3" 0.4000 103.1000 106.4500 102.0000 106.4500)
  cqP("ETCH/TOP" "3V3" 0.4000 102.0000 106.4500 100.5500 105.7000)
  cqP("ETCH/TOP" "3V3" 0.4000 121.2500 81.8000 123.7000 80.1000)
  cqP("ETCH/TOP" "3V3" 0.4000 123.7000 80.1000 130.2500 73.5500)
  cqP("ETCH/TOP" "3V3" 0.4000 130.2500 73.5500 143.8000 73.3000)
  cqP("ETCH/TOP" "3V3" 0.4000 143.8000 73.3000 143.8000 71.5000)
  cqP("ETCH/TOP" "3V3" 0.4000 143.8000 71.5000 143.8000 69.5000)
  cqP("ETCH/TOP" "3V3" 0.4000 143.8000 73.3000 144.4500 73.9500)
  cqP("ETCH/TOP" "3V3" 0.4000 144.4500 73.9500 145.4000 73.9000)
  cqP("ETCH/TOP" "3V3" 0.4000 145.4000 73.9000 146.6000 71.5000)
  cqP("ETCH/TOP" "3V3" 0.4000 143.8000 69.5000 141.3622 67.9050)
  cqP("ETCH/TOP" "3V3" 0.4000 143.8000 69.5000 144.3000 68.1500)
  cqP("ETCH/TOP" "3V3" 0.4000 144.3000 68.1500 144.6000 67.8500)
  cqP("ETCH/TOP" "3V3" 0.4000 144.6000 67.8500 146.6000 67.6000)
  cqP("ETCH/TOP" "3V3" 0.4000 146.6000 67.6000 145.9500 66.3500)
  cqP("ETCH/TOP" "3V3" 0.4000 145.9500 66.3500 146.0000 57.2500)
  cqP("ETCH/TOP" "3V3" 0.4000 146.0000 57.2500 146.2000 57.0500)
  cqP("ETCH/BOTTOM" "3V3" 0.4000 146.2000 57.0500 146.0000 55.2000)
  cqP("ETCH/TOP" "3V3" 0.4000 146.0000 55.2000 146.0000 54.5000)
  cqP("ETCH/TOP" "N09553" 0.2000 67.6000 60.6400 67.2000 60.0500)
  cqP("ETCH/TOP" "N09553" 0.2000 67.2000 60.0500 65.4000 60.2000)
  cqP("ETCH/TOP" "N09553" 0.2000 65.4000 60.2000 65.1530 60.4540)
  cqP("ETCH/TOP" "PWR3" 0.4000 80.2750 57.5200 80.2500 58.7300)
  cqP("ETCH/BOTTOM" "PWR3" 0.4000 80.2750 57.5200 79.6500 58.3000)
  cqP("ETCH/BOTTOM" "PWR3" 0.4000 79.6500 58.3000 77.8500 59.6000)
  cqP("ETCH/TOP" "PWR3" 0.4000 77.8500 59.6000 77.7500 59.5000)
  cqP("ETCH/TOP" "PWR3" 0.4000 77.7500 59.5000 77.7500 58.7300)
  cqP("ETCH/BOTTOM" "PWR3" 0.6000 78.8500 58.8500 77.8000 57.9000)
  cqP("ETCH/BOTTOM" "PWR3" 0.6000 77.8000 57.9000 77.7250 57.5200)
  cqP("ETCH/TOP" "PWR3" 0.6000 77.8500 59.6000 78.0000 60.6000)
  cqP("ETCH/TOP" "PWR3" 0.6000 78.0000 60.6000 77.9500 61.6000)
  cqP("ETCH/TOP" "PWR3" 0.6000 77.9500 61.6000 77.2520 62.1208)
  cqP("ETCH/TOP" "PWR3" 0.6000 77.2520 62.1208 75.4030 62.1208)
  cqP("ETCH/TOP" "PWR3" 0.6000 75.4030 62.1208 74.8500 61.7500)
  cqP("ETCH/TOP" "PWR3" 0.6000 74.8500 61.7500 73.4500 60.3500)
  cqP("ETCH/BOTTOM" "PWR3" 0.6000 73.4500 60.3500 72.4500 58.9000)
  cqP("ETCH/BOTTOM" "PWR3" 0.6000 72.4500 58.9000 71.9000 58.7500)
  cqP("ETCH/BOTTOM" "PWR3" 0.6000 71.9000 58.7500 71.4500 58.9500)
  cqP("ETCH/TOP" "PWR3" 0.6000 71.4500 58.9500 70.8020 60.0540)
  cqP("ETCH/TOP" "PWR3" 0.6000 70.8020 60.0540 69.0500 60.6500)
  cqP("ETCH/BOTTOM" "PWR3" 0.6000 69.0500 60.6500 66.3500 60.7000)
  cqP("ETCH/TOP" "PWR3" 0.6000 66.3500 60.7000 66.9500 60.6400)
  cqP("ETCH/BOTTOM" "PWR3" 0.6000 71.5000 58.9000 67.9300 55.0000)
  cqP("ETCH/TOP" "PWR3" 0.6000 67.9300 55.0000 63.2030 52.4540)
  cqP("ETCH/TOP" "N09603" 0.2000 91.4000 79.4000 92.0000 79.3500)
  cqP("ETCH/TOP" "N09603" 0.2000 92.0000 79.3500 92.1500 79.2000)
  cqP("ETCH/BOTTOM" "N09603" 0.2000 92.1500 79.2000 86.6000 75.7500)
  cqP("ETCH/BOTTOM" "N09603" 0.2000 86.6000 75.7500 85.9500 73.7500)
  cqP("ETCH/BOTTOM" "N09603" 0.2000 85.9500 73.7500 70.1000 63.5000)
  cqP("ETCH/TOP" "N09603" 0.2000 70.1000 63.5000 70.8020 63.2540)
  cqP("ETCH/TOP" "N09603" 0.2000 70.1000 63.5000 68.2500 62.5600)
  cqP("ETCH/TOP" "GND_EARTH" 0.4000 93.5650 107.4700 93.2050 103.0800)
  cqP("ETCH/BOTTOM" "GND_EARTH" 0.4000 93.2050 103.0800 91.7000 103.8500)
  cqP("ETCH/BOTTOM" "GND_EARTH" 0.4000 91.7000 103.8500 85.4500 103.8000)
  cqP("ETCH/BOTTOM" "GND_EARTH" 0.4000 85.4500 103.8000 84.7950 103.0800)
  cqP("ETCH/BOTTOM" "GND_EARTH" 0.4000 84.7950 103.0800 82.1000 103.4000)
  cqP("ETCH/TOP" "GND_EARTH" 0.4000 82.1000 103.4000 81.4030 103.6540)
  cqP("ETCH/TOP" "GND_EARTH" 0.4000 81.4030 103.6540 79.6020 103.6540)
  cqP("ETCH/BOTTOM" "GND_EARTH" 0.4000 84.7950 103.0800 84.4350 107.4700)
  cqP("ETCH/TOP" "GND_EARTH" 0.4000 79.6020 103.6540 62.4500 93.6000)
  cqP("ETCH/BOTTOM" "GND_EARTH" 0.4000 62.4500 93.6000 57.9500 93.6000)
  cqP("ETCH/BOTTOM" "GND_EARTH" 0.4000 57.9500 93.6000 56.9200 93.2050)
  cqP("ETCH/TOP" "GND_EARTH" 0.4000 56.9200 93.2050 52.5300 93.5650)
  cqP("ETCH/TOP" "GND_EARTH" 0.4000 56.9200 93.2050 56.1500 91.7000)
  cqP("ETCH/TOP" "GND_EARTH" 0.4000 56.1500 91.7000 56.1500 87.7500)
  cqP("ETCH/BOTTOM" "GND_EARTH" 0.4000 56.1500 87.7500 56.2000 85.4500)
  cqP("ETCH/BOTTOM" "GND_EARTH" 0.4000 56.2000 85.4500 56.9200 84.7950)
  cqP("ETCH/BOTTOM" "GND_EARTH" 0.4000 56.9200 84.7950 55.2000 82.8500)
  cqP("ETCH/TOP" "GND_EARTH" 0.4000 55.2000 82.8500 55.8540 82.3980)
  cqP("ETCH/TOP" "GND_EARTH" 0.4000 55.8540 82.3980 55.8540 80.5970)
  cqP("ETCH/BOTTOM" "GND_EARTH" 0.4000 55.2000 82.8500 54.6000 82.3000)
  cqP("ETCH/BOTTOM" "GND_EARTH" 0.4000 54.6000 82.3000 53.1500 81.7500)
  cqP("ETCH/TOP" "GND_EARTH" 0.4000 53.1500 81.7500 52.6540 82.3980)
  cqP("ETCH/TOP" "GND_EARTH" 0.4000 53.1500 81.7500 52.6540 80.5970)
  cqP("ETCH/TOP" "GND_EARTH" 0.4000 52.6540 82.3980 52.5300 84.4350)
  cqP("ETCH/TOP" "GND_EARTH" 0.4000 52.6540 80.5970 52.0000 79.0000)
  cqP("ETCH/TOP" "GND_EARTH" 0.4000 52.0000 79.0000 52.0000 75.9500)
  cqP("ETCH/TOP" "GND_EARTH" 0.4000 52.0000 75.9500 52.5300 75.5650)
  cqP("ETCH/TOP" "GND_EARTH" 0.4000 52.5300 75.5650 56.9200 75.2050)
  cqP("ETCH/TOP" "GND_EARTH" 0.4000 56.9200 75.2050 56.1500 73.7000)
  cqP("ETCH/TOP" "GND_EARTH" 0.4000 56.1500 73.7000 56.1500 69.7500)
  cqP("ETCH/BOTTOM" "GND_EARTH" 0.4000 56.1500 69.7500 56.2000 67.4500)
  cqP("ETCH/BOTTOM" "GND_EARTH" 0.4000 56.2000 67.4500 56.9200 66.7950)
  cqP("ETCH/BOTTOM" "GND_EARTH" 0.4000 56.9200 66.7950 52.5300 66.4350)
  cqP("ETCH/TOP" "GND_EARTH" 0.4000 56.9200 66.7950 58.2000 66.5500)
  cqP("ETCH/TOP" "GND_EARTH" 0.4000 58.2000 66.5500 60.5500 67.3500)
  cqP("ETCH/TOP" "GND_EARTH" 0.4000 60.5500 67.3500 65.4000 67.4500)
  cqP("ETCH/BOTTOM" "GND_EARTH" 0.4000 65.4000 67.4500 69.9000 62.7000)
  cqP("ETCH/BOTTOM" "GND_EARTH" 0.4000 69.9000 62.7000 72.5000 62.7000)
  cqP("ETCH/TOP" "GND_EARTH" 0.4000 72.5000 62.7000 73.2030 62.4540)
  cqP("ETCH/TOP" "GND_EARTH" 0.4000 72.5500 62.6500 71.5000 61.4000)
  cqP("ETCH/TOP" "GND_EARTH" 0.4000 71.5000 61.4000 71.5000 60.8000)
  cqP("ETCH/TOP" "GND_EARTH" 0.4000 71.5000 60.8000 72.4500 59.7000)
  cqP("ETCH/TOP" "GND_EARTH" 0.4000 72.4500 59.7000 72.7030 59.4540)
  cqP("ETCH/TOP" "GND_EARTH" 0.4000 72.7030 59.4540 74.7950 56.9200)
  cqP("ETCH/TOP" "GND_EARTH" 0.4000 74.7950 56.9200 74.4350 52.5300)
  cqP("ETCH/TOP" "GND_EARTH" 0.4000 74.7950 56.9200 76.3000 56.1500)
  cqP("ETCH/TOP" "GND_EARTH" 0.4000 76.3000 56.1500 80.2500 56.1500)
  cqP("ETCH/BOTTOM" "GND_EARTH" 0.4000 80.2500 56.1500 82.5500 56.2000)
  cqP("ETCH/BOTTOM" "GND_EARTH" 0.4000 82.5500 56.2000 83.2050 56.9200)
  cqP("ETCH/BOTTOM" "GND_EARTH" 0.4000 83.2050 56.9200 83.5650 52.5300)
  cqP("ETCH/TOP" "GND_EARTH" 0.4000 83.5650 52.5300 92.4350 52.5300)
  cqP("ETCH/TOP" "GND_EARTH" 0.4000 92.4350 52.5300 92.7950 56.9200)
  cqP("ETCH/TOP" "GND_EARTH" 0.4000 92.7950 56.9200 94.3000 56.1500)
  cqP("ETCH/TOP" "GND_EARTH" 0.4000 94.3000 56.1500 98.2500 56.1500)
  cqP("ETCH/BOTTOM" "GND_EARTH" 0.4000 98.2500 56.1500 100.5500 56.2000)
  cqP("ETCH/BOTTOM" "GND_EARTH" 0.4000 100.5500 56.2000 101.2050 56.9200)
  cqP("ETCH/BOTTOM" "GND_EARTH" 0.4000 101.2050 56.9200 103.3000 56.6500)
  cqP("ETCH/TOP" "GND_EARTH" 0.4000 103.3000 56.6500 104.6020 59.3040)
  cqP("ETCH/TOP" "GND_EARTH" 0.4000 104.6020 59.3040 106.4530 59.8540)
  cqP("ETCH/BOTTOM" "GND_EARTH" 0.4000 101.2050 56.9200 101.5650 52.5300)
  cqP("ETCH/TOP" "VDD12" 0.2000 88.2000 83.4000 88.2500 82.8000)
  cqP("ETCH/TOP" "VDD12" 0.2000 88.2500 82.8000 90.4500 82.7500)
  cqP("ETCH/TOP" "VDD12" 0.2000 90.4500 82.7500 90.6000 82.8500)
  cqP("ETCH/TOP" "VDD12" 0.2000 90.6000 82.8500 90.6000 83.4000)
  cqP("ETCH/TOP" "VDD12" 0.5000 91.1500 83.2000 91.9000 83.8500)
  cqP("ETCH/TOP" "VDD12" 0.5000 91.9000 83.8500 92.6500 84.8500)
  cqP("ETCH/BOTTOM" "VDD12" 0.5000 92.6500 84.8500 92.4000 86.4000)
  cqP("ETCH/TOP" "VDD12" 0.5000 92.4000 86.4000 91.2000 85.2000)
  cqP("ETCH/BOTTOM" "VDD12" 0.5000 91.2000 85.2000 90.5970 84.7540)
  cqP("ETCH/TOP" "VDD12" 0.5000 92.6500 84.8500 93.7540 84.9980)
  cqP("ETCH/TOP" "VDD12" 0.2000 88.2500 82.8000 85.5500 82.5500)
  cqP("ETCH/TOP" "VDD12" 0.2000 85.5500 82.5500 85.2500 82.2500)
  cqP("ETCH/TOP" "VDD12" 0.2000 85.2500 82.2500 85.2000 81.0500)
  cqP("ETCH/TOP" "VDD12" 0.2000 85.2000 81.0500 84.6000 81.0000)
  cqP("ETCH/TOP" "VDD12" 0.4000 85.3500 82.3500 85.3500 82.4500)
  cqP("ETCH/BOTTOM" "VDD12" 0.4000 85.3500 82.4500 83.2460 80.9980)
  cqP("ETCH/TOP" "VDD12" 0.2000 85.2000 81.0500 85.2500 78.3500)
  cqP("ETCH/TOP" "VDD12" 0.2000 85.2500 78.3500 85.1500 78.2000)
  cqP("ETCH/TOP" "VDD12" 0.2000 85.1500 78.2000 84.6000 78.2000)
  cqP("ETCH/BOTTOM" "VDD12" 0.5000 83.2460 80.9980 83.2460 78.1980)
  cqP("ETCH/BOTTOM" "VDD12" 0.4000 83.2460 78.1980 84.9000 76.9000)
  cqP("ETCH/TOP" "VDD12" 0.4000 84.9000 76.9000 85.3000 76.9000)
  cqP("ETCH/BOTTOM" "VDD12" 0.5000 84.9000 76.9000 85.6000 76.2500)
  cqP("ETCH/BOTTOM" "VDD12" 0.5000 85.6000 76.2500 85.6500 75.5000)
  cqP("ETCH/BOTTOM" "VDD12" 0.5000 85.6500 75.5000 85.4030 75.2460)
  cqP("ETCH/TOP" "VDD12" 0.2000 85.4000 76.6000 85.4500 77.2000)
  cqP("ETCH/TOP" "VDD12" 0.2000 85.4500 77.2000 87.6500 77.2500)
  cqP("ETCH/TOP" "VDD12" 0.2000 87.6500 77.2500 87.8000 77.1500)
  cqP("ETCH/TOP" "VDD12" 0.2000 87.8000 77.1500 87.8000 76.6000)
  cqP("ETCH/TOP" "VDD12" 0.2000 87.8000 77.1500 87.9500 77.2500)
  cqP("ETCH/TOP" "VDD12" 0.2000 87.9500 77.2500 90.5500 77.2000)
  cqP("ETCH/TOP" "VDD12" 0.2000 90.5500 77.2000 92.0500 74.6000)
  cqP("ETCH/BOTTOM" "VDD12" 0.2000 92.0500 74.6000 91.6000 73.3500)
  cqP("ETCH/BOTTOM" "VDD12" 0.2000 91.6000 73.3500 90.8500 72.3500)
  cqP("ETCH/TOP" "VDD12" 0.2000 90.8500 72.3500 89.5000 72.9000)
  cqP("ETCH/TOP" "VDD12" 0.2000 89.5000 72.9000 89.1000 73.3000)
  cqP("ETCH/BOTTOM" "VDD12" 0.2000 89.1000 73.3000 89.3500 73.7500)
  cqP("ETCH/BOTTOM" "VDD12" 0.2000 89.3500 73.7500 89.3500 74.6000)
  cqP("ETCH/BOTTOM" "VDD12" 0.2000 89.3500 74.6000 88.8020 75.2460)
  cqP("ETCH/BOTTOM" "VDD12" 0.5000 89.1500 74.8500 90.6020 75.2460)
  cqP("ETCH/TOP" "VDD12" 0.2000 90.5500 77.2000 90.8000 78.9500)
  cqP("ETCH/TOP" "VDD12" 0.2000 90.8000 78.9500 91.4000 79.0000)
  cqP("ETCH/BOTTOM" "VDD12" 0.5000 92.6500 84.8500 94.7540 80.4030)
  cqP("ETCH/BOTTOM" "VDD12" 0.5000 94.7540 80.4030 95.5540 79.0020)
  cqP("ETCH/BOTTOM" "VDD12" 0.5000 95.5540 79.0020 96.1500 79.7000)
  cqP("ETCH/BOTTOM" "VDD12" 0.5000 96.1500 79.7000 97.1500 79.6500)
  cqP("ETCH/BOTTOM" "VDD12" 0.5000 97.1500 79.6500 148.1000 57.7500)
  cqP("ETCH/TOP" "VDD12" 0.5000 148.1000 57.7500 149.1336 58.5000)
  cqP("ETCH/TOP" "N08722" 0.2000 63.2500 98.6400 63.8500 99.2500)
  cqP("ETCH/BOTTOM" "N08722" 0.2000 63.8500 99.2500 64.9000 100.8000)
  cqP("ETCH/TOP" "N08722" 0.2000 64.9000 100.8000 65.6020 101.1208)
  cqP("ETCH/TOP" "RESET_N" 0.2000 91.4000 82.6000 93.6500 84.2500)
  cqP("ETCH/BOTTOM" "RESET_N" 0.2000 93.6500 84.2500 94.3500 82.5000)
  cqP("ETCH/BOTTOM" "RESET_N" 0.2000 94.3500 82.5000 103.3500 77.5500)
  cqP("ETCH/BOTTOM" "RESET_N" 0.2000 103.3500 77.5500 135.3000 64.0500)
  cqP("ETCH/BOTTOM" "RESET_N" 0.2000 135.3000 64.0500 139.9500 64.0500)
  cqP("ETCH/TOP" "RESET_N" 0.2000 139.9500 64.0500 141.3622 64.0950)
  cqP("ETCH/TOP" "RESET_N" 0.2000 141.3622 64.0950 147.0668 54.5000)
  cqP("ETCH/TOP" "RESET_N" 0.2000 147.0668 54.5000 146.0000 52.5000)
  cqP("ETCH/TOP" "RESET_N" 0.2000 147.0668 54.5000 150.9250 54.0750)
  cqP("ETCH/TOP" "RESET_N" 0.2000 150.9250 54.0750 155.0750 54.0750)
  cqP("ETCH/TOP" "N10586" 0.2000 91.4000 79.8000 93.3500 79.7500)
  cqP("ETCH/TOP" "N10586" 0.2000 93.3500 79.7500 93.5000 79.6000)
  cqP("ETCH/BOTTOM" "N10586" 0.2000 93.5000 79.6000 94.0500 79.2000)
  cqP("ETCH/BOTTOM" "N10586" 0.2000 94.0500 79.2000 94.3500 78.6500)
  cqP("ETCH/BOTTOM" "N10586" 0.2000 94.3500 78.6500 94.3500 77.7500)
  cqP("ETCH/BOTTOM" "N10586" 0.2000 94.3500 77.7500 91.1500 74.5500)
  cqP("ETCH/BOTTOM" "N10586" 0.2000 91.1500 74.5500 91.1500 73.7500)
  cqP("ETCH/BOTTOM" "N10586" 0.2000 91.1500 73.7500 80.4000 63.1000)
  cqP("ETCH/BOTTOM" "N10586" 0.2000 80.4000 63.1000 71.3500 61.9500)
  cqP("ETCH/BOTTOM" "N10586" 0.2000 71.3500 61.9500 70.5000 61.1500)
  cqP("ETCH/BOTTOM" "N10586" 0.2000 70.5000 61.1500 70.0000 61.1500)
  cqP("ETCH/BOTTOM" "N10586" 0.2000 70.0000 61.1500 68.5000 62.6000)
  cqP("ETCH/BOTTOM" "N10586" 0.2000 68.5000 62.6000 64.9000 62.6000)
  cqP("ETCH/BOTTOM" "N10586" 0.2000 64.9000 62.6000 64.1000 62.7000)
  cqP("ETCH/TOP" "N10586" 0.2000 64.1000 62.7000 63.4020 62.8540)
  cqP("ETCH/TOP" "N10586" 0.2000 63.4020 62.8540 61.0500 62.5600)
  cqP("ETCH/BOTTOM" "VDD33" 0.4000 85.0000 84.6000 85.4980 84.7540)
  cqP("ETCH/BOTTOM" "VDD33" 0.4000 85.4980 84.7540 88.8980 84.7540)
  cqP("ETCH/BOTTOM" "VDD33" 0.4000 88.8980 84.7540 90.2000 83.4000)
  cqP("ETCH/BOTTOM" "VDD33" 0.4000 88.8980 84.7540 89.9500 85.7500)
  cqP("ETCH/BOTTOM" "VDD33" 0.4000 89.9500 85.7500 89.9500 87.3000)
  cqP("ETCH/BOTTOM" "VDD33" 0.4000 89.9500 87.3000 90.1980 87.5540)
  cqP("ETCH/TOP" "VDD33" 0.4000 91.1500 84.2000 93.7540 86.7970)
  cqP("ETCH/BOTTOM" "VDD33" 0.4000 90.2000 83.4000 92.7500 79.4000)
  cqP("ETCH/BOTTOM" "VDD33" 0.4000 92.7500 79.4000 92.6500 78.8000)
  cqP("ETCH/BOTTOM" "VDD33" 0.4000 92.6500 78.8000 91.4000 78.2000)
  cqP("ETCH/BOTTOM" "VDD33" 0.4000 91.4000 78.2000 87.1020 75.2460)
  cqP("ETCH/BOTTOM" "VDD33" 0.4000 85.0000 84.6000 81.7000 83.8500)
  cqP("ETCH/BOTTOM" "VDD33" 0.4000 81.7000 83.8500 81.3500 83.4500)
  cqP("ETCH/BOTTOM" "VDD33" 0.4000 81.3500 83.4500 81.6000 76.6000)
  cqP("ETCH/BOTTOM" "VDD33" 0.4000 81.6000 76.6000 82.2000 75.9500)
  cqP("ETCH/BOTTOM" "VDD33" 0.4000 82.2000 75.9500 84.9000 75.9500)
  cqP("ETCH/BOTTOM" "VDD33" 0.4000 92.7540 78.2030 92.4000 76.5500)
  cqP("ETCH/TOP" "VDD33" 0.4000 92.4000 76.5500 92.6500 74.4000)
  cqP("ETCH/TOP" "VDD33" 0.4000 92.6500 74.4000 92.5000 74.1500)
  cqP("ETCH/BOTTOM" "VDD33" 0.4000 92.5000 74.1500 91.3000 71.8000)
  cqP("ETCH/BOTTOM" "VDD33" 0.4000 91.3000 71.8000 90.8000 71.6500)
  cqP("ETCH/BOTTOM" "VDD33" 0.4000 90.8000 71.6500 90.0500 71.8500)
  cqP("ETCH/TOP" "VDD33" 0.4000 90.0500 71.8500 86.5000 72.2000)
  cqP("ETCH/BOTTOM" "VDD33" 0.4000 86.5000 72.2000 85.8020 72.4460)
  cqP("ETCH/TOP" "VDD33" 0.4000 92.6500 74.4000 101.7500 72.6000)
  cqP("ETCH/BOTTOM" "VDD33" 0.4000 101.7500 72.6000 113.8500 71.7000)
  cqP("ETCH/TOP" "VDD33" 0.4000 113.8500 71.7000 143.0500 71.7000)
  cqP("ETCH/BOTTOM" "VDD33" 0.4000 143.0500 71.7000 147.1500 72.1500)
  cqP("ETCH/TOP" "VDD33" 0.4000 147.1500 72.1500 147.6668 71.5000)
  cqP("ETCH/TOP" "N08734" 0.2000 91.4000 80.2000 93.7500 80.1500)
  cqP("ETCH/BOTTOM" "N08734" 0.2000 93.7500 80.1500 91.7500 85.3000)
  cqP("ETCH/BOTTOM" "N08734" 0.2000 91.7500 85.3000 91.7000 86.6500)
  cqP("ETCH/BOTTOM" "N08734" 0.2000 91.7000 86.6500 91.2500 89.5500)
  cqP("ETCH/BOTTOM" "N08734" 0.2000 91.2500 89.5500 81.0000 99.8000)
  cqP("ETCH/BOTTOM" "N08734" 0.2000 81.0000 99.8000 66.3000 99.8000)
  cqP("ETCH/TOP" "N08734" 0.2000 66.3000 99.8000 65.6020 100.0540)
  cqP("ETCH/TOP" "N08734" 0.2000 65.6020 100.0540 63.2500 100.5600)
  let((p) p = outfile(strcat(CQDIR "claude_rt_r59.txt"))
    fprintf(p "NP %d NV %d\nEP %L\nEV %L\n" cqNP cqNV cqEP cqEV) close(p))
  printf("route r59: paths %d vias %d errP %d errV %d\n" cqNP cqNV length(cqEP) length(cqEV))
  t)
cqRoute_r59()
