; copy axlFilm* / artwork docs from the install so Claude can read them (Claude)
CQDIR = "C:/Users/Maria Priscila Quiro/OneDrive/Documentos/Escritorio/Orcad/cdssetup/workspace/projects/hub/"
procedure(cqCopy(src dst)
  let((i o l)
    i = infile(src) o = outfile(dst)
    when(i && o while(gets(l i) fprintf(o "%s" l)))
    when(i close(i)) when(o close(o)) i))
procedure(cqDocs55()
  let((p roots fs n)
    p = outfile(strcat(CQDIR "claude_c55docs.txt"))
    roots = list("c:/cadence/orcadx_25.1/share/pcb/examples/skill/DOC/FUNCS" "c:/cadence/orcadx_25.1/share/pcb/examples/skill/DOC" "c:/cadence/orcadx_25.1/share/pcb/examples/skill")
    foreach(r roots fprintf(p "DIR %s %L\n" r isDir(r)))
    fs = getDirFiles("c:/cadence/orcadx_25.1/share/pcb/examples/skill/DOC/FUNCS")
    fprintf(p "N %L\n" length(fs))
    n = 0
    foreach(f fs
      when(rexMatchp("[Ff]ilm\\|[Aa]rtwork\\|[Nn][Cc]" f)
        fprintf(p "F %s\n" f)
        cqCopy(strcat("c:/cadence/orcadx_25.1/share/pcb/examples/skill/DOC/FUNCS/" f) strcat(CQDIR "claude_doc_" f ".txt"))
        n = n + 1))
    fprintf(p "COPIED %d\nFNS %L\n" n mapcar(lambda((s) list(s isCallable(s))) '(axlFilmCreate axlDBCreateFilmRec axlfcreate axlArtworkCreate axlFilmList axlDBGetFilms)))
    fprintf(p "FILMS %L\n" car(errset(axlGetParam("artwork")->??  t)))
    close(p) printf("docs55 done\n") t))
cqDocs55()
