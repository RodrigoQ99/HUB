; recreate artwork films: silk 0.15 undefined width, vias tented (no VIA CLASS soldermask) (Claude)
CQDIR = "C:/Users/Maria Priscila Quiro/OneDrive/Documentos/Escritorio/Orcad/cdssetup/workspace/projects/hub/"
cqFilms = list(
  list("L1_TOP"      0.0 list("ETCH/TOP" "PIN/TOP" "VIA CLASS/TOP"))
  list("L2_GND"      0.0 list("ETCH/GND" "PIN/GND" "VIA CLASS/GND"))
  list("L3_PWR"      0.0 list("ETCH/PWR" "PIN/PWR" "VIA CLASS/PWR"))
  list("L4_BOTTOM"   0.0 list("ETCH/BOTTOM" "PIN/BOTTOM" "VIA CLASS/BOTTOM"))
  list("SILK_TOP"    0.15 list("BOARD GEOMETRY/SILKSCREEN_TOP" "PACKAGE GEOMETRY/SILKSCREEN_TOP" "REF DES/SILKSCREEN_TOP"))
  list("SILK_BOTTOM" 0.15 list("BOARD GEOMETRY/SILKSCREEN_BOTTOM" "PACKAGE GEOMETRY/SILKSCREEN_BOTTOM" "REF DES/SILKSCREEN_BOTTOM"))
  list("MASK_TOP"    0.0 list("BOARD GEOMETRY/SOLDERMASK_TOP" "PACKAGE GEOMETRY/SOLDERMASK_TOP" "PIN/SOLDERMASK_TOP"))
  list("MASK_BOTTOM" 0.0 list("BOARD GEOMETRY/SOLDERMASK_BOTTOM" "PACKAGE GEOMETRY/SOLDERMASK_BOTTOM" "PIN/SOLDERMASK_BOTTOM"))
  list("PASTE_TOP"   0.0 list("PACKAGE GEOMETRY/PASTEMASK_TOP" "PIN/PASTEMASK_TOP"))
  list("PASTE_BOTTOM" 0.0 list("PACKAGE GEOMETRY/PASTEMASK_BOTTOM" "PIN/PASTEMASK_BOTTOM"))
  list("ASSY_TOP"    0.1 list("PACKAGE GEOMETRY/ASSEMBLY_TOP" "REF DES/ASSEMBLY_TOP" "COMPONENT VALUE/ASSEMBLY_TOP" "BOARD GEOMETRY/DESIGN_OUTLINE"))
  list("ASSY_BOTTOM" 0.1 list("PACKAGE GEOMETRY/ASSEMBLY_BOTTOM" "REF DES/ASSEMBLY_BOTTOM" "COMPONENT VALUE/ASSEMBLY_BOTTOM" "BOARD GEOMETRY/DESIGN_OUTLINE"))
  list("OUTLINE"     0.1 list("BOARD GEOMETRY/DESIGN_OUTLINE" "BOARD GEOMETRY/OUTLINE" "BOARD GEOMETRY/DIMENSION"))
  list("DRILL_DWG"   0.1 list("MANUFACTURING/NCLEGEND-1-4" "BOARD GEOMETRY/DESIGN_OUTLINE")))
procedure(cqLayerOk(l)
  let((cls sub subs)
    cls = car(parseString(l "/")) sub = cadr(parseString(l "/"))
    subs = car(errset(axlSubclasses(cls) nil))
    and(sub member(upperCase(sub) mapcar('upperCase subs)))))
procedure(cqFilms73()
  let((p ok lays seq)
    p = outfile(strcat(CQDIR "claude_c73.txt"))
    seq = 1
    foreach(f cqFilms
      lays = setof(l caddr(f) cqLayerOk(l))
      ok = car(errset(axlFilmCreate(car(f) ?undefineLineWidth cadr(f) ?sequence seq ?layers lays) t))
      fprintf(p "FILM %s ok=%L layers=%L dropped=%L\n" car(f) ok lays setof(l caddr(f) !member(l lays)))
      seq = seq + 1)
    fprintf(p "ALL %L\n" axlGetParam("artwork")->groupMembers)
    axlShell("drc update")
    fprintf(p "NDRC %d\n" length(axlDBGetDesign()->drcs))
    foreach(x axlDBGetDesign()->drcs fprintf(p "DRC %L %L %L\n" x->xy x->layer x->name))
    close(p) printf("films73 done\n") t))
cqFilms73()
