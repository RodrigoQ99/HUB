; move R117 (+0.5,+6.5) above Y1 and C75 (+2.0,+0.5) on BOTTOM, needed by the routing plan (Claude)
CQDIR = "C:/Users/Maria Priscila Quiro/OneDrive/Documentos/Escritorio/Orcad/cdssetup/workspace/projects/hub/"
procedure(cqMv(p ref dx dy)
  let((s r)
    s = car(setof(x axlDBGetDesign()->symbols x->refdes == ref))
    fprintf(p "%s BEFORE %L mir %L pins %L\n" ref s->xy s->isMirrored mapcar(lambda((q) list(q->number q->xy)) s->pins))
    r = errset(axlTransformObject(s ?move dx:dy) t)
    fprintf(p "%s TRANSFORM %L\n" ref r)
    s = car(setof(x axlDBGetDesign()->symbols x->refdes == ref))
    fprintf(p "%s AFTER %L pins %L\n" ref s->xy mapcar(lambda((q) list(q->number q->xy)) s->pins))))
procedure(cqMove58()
  let((p)
    p = outfile(strcat(CQDIR "claude_c58log.txt"))
    cqMv(p "R117" 0.5 6.5)
    cqMv(p "C75" 2.0 0.5)
    close(p) printf("move58 done\n") t))
cqMove58()
