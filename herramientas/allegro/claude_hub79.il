; assembly drawing cleanup: missing refdes, drop part-number texts, ASSY films (Claude)
CQDIR = "C:/Users/Maria Priscila Quiro/OneDrive/Documentos/Escritorio/Orcad/cdssetup/workspace/projects/hub/"
procedure(cqRun79()
 let((p d sy n o r lays ok)
  d = axlDBGetDesign() n = 0
  p = outfile(strcat(CQDIR "claude_c79.txt"))
  foreach(s d->symbols
    when(member(s->refdes list("Q1" "U15" "U14" "U16" "SW4"))
      foreach(c s->children
        when(c->objType == "text" && c->layer == "PACKAGE GEOMETRY/ASSEMBLY_TOP" && strlen(c->text) > 3
          fprintf(p "DEL %s %s\n" s->refdes c->text) axlDeleteObject(c)))))
  sy = car(setof(x d->symbols x->refdes == "SW3"))
  o = make_axlTextOrientation(?textBlock "27" ?rotation 0.0 ?mirrored nil ?justify "center")
  r = car(errset(axlDBCreateText("SW3" list(118.0000 103.7500) o "BOARD GEOMETRY/ASSEMBLY_TOP" sy) t))
  fprintf(p "ADD SW3 %L\n" r)
  sy = car(setof(x d->symbols x->refdes == "U12"))
  o = make_axlTextOrientation(?textBlock "25" ?rotation 0.0 ?mirrored nil ?justify "center")
  r = car(errset(axlDBCreateText("U12" list(101.5000 104.0000) o "BOARD GEOMETRY/ASSEMBLY_TOP" sy) t))
  fprintf(p "ADD U12 %L\n" r)
  sy = car(setof(x d->symbols x->refdes == "U13"))
  o = make_axlTextOrientation(?textBlock "25" ?rotation 0.0 ?mirrored nil ?justify "center")
  r = car(errset(axlDBCreateText("U13" list(122.2000 80.1000) o "BOARD GEOMETRY/ASSEMBLY_TOP" sy) t))
  fprintf(p "ADD U13 %L\n" r)
  sy = car(setof(x d->symbols x->refdes == "U4"))
  o = make_axlTextOrientation(?textBlock "25" ?rotation 0.0 ?mirrored nil ?justify "center")
  r = car(errset(axlDBCreateText("U4" list(62.6000 99.1000) o "BOARD GEOMETRY/ASSEMBLY_TOP" sy) t))
  fprintf(p "ADD U4 %L\n" r)
  sy = car(setof(x d->symbols x->refdes == "U5"))
  o = make_axlTextOrientation(?textBlock "25" ?rotation 0.0 ?mirrored nil ?justify "center")
  r = car(errset(axlDBCreateText("U5" list(60.4000 61.1000) o "BOARD GEOMETRY/ASSEMBLY_TOP" sy) t))
  fprintf(p "ADD U5 %L\n" r)
  sy = car(setof(x d->symbols x->refdes == "U6"))
  o = make_axlTextOrientation(?textBlock "25" ?rotation 0.0 ?mirrored nil ?justify "center")
  r = car(errset(axlDBCreateText("U6" list(67.6000 61.1000) o "BOARD GEOMETRY/ASSEMBLY_TOP" sy) t))
  fprintf(p "ADD U6 %L\n" r)
  sy = car(setof(x d->symbols x->refdes == "U7"))
  o = make_axlTextOrientation(?textBlock "25" ?rotation 0.0 ?mirrored nil ?justify "center")
  r = car(errset(axlDBCreateText("U7" list(112.8500 58.7000) o "BOARD GEOMETRY/ASSEMBLY_TOP" sy) t))
  fprintf(p "ADD U7 %L\n" r)
  sy = car(setof(x d->symbols x->refdes == "Y1"))
  o = make_axlTextOrientation(?textBlock "25" ?rotation 0.0 ?mirrored nil ?justify "center")
  r = car(errset(axlDBCreateText("Y1" list(82.0000 88.3000) o "BOARD GEOMETRY/ASSEMBLY_TOP" sy) t))
  fprintf(p "ADD Y1 %L\n" r)
  foreach(f list(list("ASSY_TOP" 11 list("PACKAGE GEOMETRY/ASSEMBLY_TOP" "REF DES/ASSEMBLY_TOP" "BOARD GEOMETRY/ASSEMBLY_TOP" "BOARD GEOMETRY/DESIGN_OUTLINE"))
                list("ASSY_BOTTOM" 12 list("PACKAGE GEOMETRY/ASSEMBLY_BOTTOM" "REF DES/ASSEMBLY_BOTTOM" "BOARD GEOMETRY/ASSEMBLY_BOTTOM" "BOARD GEOMETRY/DESIGN_OUTLINE")))
    lays = setof(l caddr(f) member(upperCase(cadr(parseString(l "/"))) mapcar(quote(upperCase) axlSubclasses(car(parseString(l "/"))))))
    ok = car(errset(axlFilmCreate(car(f) ?undefineLineWidth 0.1 ?sequence cadr(f) ?layers lays) t))
    fprintf(p "FILM %s %L %L\n" car(f) ok lays))
  close(p) printf("run79 done\n") t))
cqRun79()
