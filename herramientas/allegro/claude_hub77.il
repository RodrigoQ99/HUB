; clip package silkscreen off pads, U1 corner marks + pin-1 dot, move pin-1 asterisks (Claude) - generated by clip2/gen77
CQDIR = "C:/Users/Maria Priscila Quiro/OneDrive/Documentos/Escritorio/Orcad/cdssetup/workspace/projects/hub/"
cqLog77 = nil
cqSym77 = makeTable("cqSym77" nil)
foreach(s axlDBGetDesign()->symbols when(s->refdes cqSym77[s->refdes] = s))
procedure(cqNear(a b) and(abs(car(a)-car(b)) < 0.006 abs(cadr(a)-cadr(b)) < 0.006))
procedure(cqSegMatch(se tg) or(and(cqNear(car(se) car(tg)) cqNear(cadr(se) cadr(tg))) and(cqNear(car(se) cadr(tg)) cqNear(cadr(se) car(tg)))))
procedure(cqLine77(a b w)
  let((p r) p = axlPathStart(list(a) w) axlPathLine(p w b)
    r = car(errset(axlDBCreatePath(p "BOARD GEOMETRY/SILKSCREEN_TOP" nil nil) t))
    unless(r cqLog77 = cons(sprintf(nil "LINE-FAIL %L %L" a b) cqLog77)) r))
; delete path/line children of ref matching any target segment; re-create untargeted sibling segments
procedure(cqDelSeg77(ref tgs)
  let((s segs keep)
    s = cqSym77[ref]
    when(s foreach(c s->children
      when(c->layer == "PACKAGE GEOMETRY/SILKSCREEN_TOP" && member(c->objType list("path" "line" "arc"))
        segs = if(c->objType == "path" c->segments list(c))
        when(exists(sg segs exists(tg tgs cqSegMatch(sg->startEnd tg)))
          foreach(sg segs
            unless(exists(tg tgs cqSegMatch(sg->startEnd tg))
              if(sg->objType == "arc" then cqLog77 = cons(sprintf(nil "ARC-SIBLING %s %L" ref sg->startEnd) cqLog77)
              else cqLine77(car(sg->startEnd) cadr(sg->startEnd) if(sg->width > 0 sg->width 0.15)) cqLog77 = cons(sprintf(nil "SIBLING %s %L" ref sg->startEnd) cqLog77))))
          cqLog77 = cons(sprintf(nil "DELPATH %s n=%d" ref length(segs)) cqLog77) axlDeleteObject(c)))))))
procedure(cqDelShape77(ref bb)
  let((s) s = cqSym77[ref]
    when(s foreach(c s->children
      when(c->layer == "PACKAGE GEOMETRY/SILKSCREEN_TOP" && !member(c->objType list("path" "line" "arc" "text")) && cqNear(car(c->bBox) car(bb)) && cqNear(cadr(c->bBox) cadr(bb))
        cqLog77 = cons(sprintf(nil "DELSHAPE %s %L" ref c->objType) cqLog77) axlDeleteObject(c))))))
procedure(cqMoveTxt77(ref txt dx dy)
  let((s) s = cqSym77[ref]
    when(s foreach(c s->children
      when(c->objType == "text" && c->text == txt && c->layer == "PACKAGE GEOMETRY/SILKSCREEN_TOP"
        axlTransformObject(c ?move list(dx dy)) cqLog77 = cons(sprintf(nil "MOVETXT %s %s" ref txt) cqLog77))))))
procedure(cqRun77()
 let((p)
  cqDelShape77("J12" list(list(84.0500 100.0000) list(93.9500 110.0000)))
  cqDelShape77("J1" list(list(50.0000 84.0500) list(60.0000 93.9500)))
  cqDelShape77("J2" list(list(50.0000 66.0500) list(60.0000 75.9500)))
  cqDelShape77("J3" list(list(74.0500 50.0000) list(83.9500 60.0000)))
  cqDelShape77("J4" list(list(92.0500 50.0000) list(101.9500 60.0000)))
  cqDelShape77("U8" list(list(111.4855 78.0600) list(114.9145 83.1400)))
  cqDelShape77("U11" list(list(99.7680 78.0600) list(103.8320 83.1400)))
  cqDelSeg77("U1" list(list(list(84.5000 76.5000) list(91.5000 76.5000)) list(list(91.5000 76.5000) list(91.5000 83.5000)) list(list(91.5000 83.5000) list(84.5000 83.5000)) list(list(84.5000 83.5000) list(84.5000 76.5000))))
  cqDelSeg77("J5" list(list(list(142.6000 100.0000) list(158.6000 100.0000)) list(list(146.6000 102.2000) list(146.6000 105.0000)) list(list(146.6000 105.0000) list(152.4000 105.0000)) list(list(146.6000 95.0000) list(146.6000 97.9000))))
  cqLine77(list(84.0500 100.0000) list(93.9500 100.0000) 0.1500)
  cqLine77(list(93.9500 100.0000) list(93.9500 106.4950) 0.1500)
  cqLine77(list(93.9500 108.4450) list(93.9500 109.7750) 0.1500)
  cqLine77(list(84.0500 109.7750) list(84.0500 108.4450) 0.1500)
  cqLine77(list(84.0500 106.4950) list(84.0500 100.0000) 0.1500)
  cqLine77(list(50.2250 84.0500) list(51.5550 84.0500) 0.1500)
  cqLine77(list(53.5050 84.0500) list(60.0000 84.0500) 0.1500)
  cqLine77(list(60.0000 84.0500) list(60.0000 93.9500) 0.1500)
  cqLine77(list(60.0000 93.9500) list(53.5050 93.9500) 0.1500)
  cqLine77(list(51.5550 93.9500) list(50.2250 93.9500) 0.1500)
  cqLine77(list(50.2250 66.0500) list(51.5550 66.0500) 0.1500)
  cqLine77(list(53.5050 66.0500) list(60.0000 66.0500) 0.1500)
  cqLine77(list(60.0000 66.0500) list(60.0000 75.9500) 0.1500)
  cqLine77(list(60.0000 75.9500) list(53.5050 75.9500) 0.1500)
  cqLine77(list(51.5550 75.9500) list(50.2250 75.9500) 0.1500)
  cqLine77(list(83.9500 50.2250) list(83.9500 51.5550) 0.1500)
  cqLine77(list(83.9500 53.5050) list(83.9500 60.0000) 0.1500)
  cqLine77(list(83.9500 60.0000) list(74.0500 60.0000) 0.1500)
  cqLine77(list(74.0500 60.0000) list(74.0500 53.5050) 0.1500)
  cqLine77(list(74.0500 51.5550) list(74.0500 50.2250) 0.1500)
  cqLine77(list(101.9500 50.2250) list(101.9500 51.5550) 0.1500)
  cqLine77(list(101.9500 53.5050) list(101.9500 60.0000) 0.1500)
  cqLine77(list(101.9500 60.0000) list(92.0500 60.0000) 0.1500)
  cqLine77(list(92.0500 60.0000) list(92.0500 53.5050) 0.1500)
  cqLine77(list(92.0500 51.5550) list(92.0500 50.2250) 0.1500)
  cqLine77(list(111.4855 78.0600) list(114.9145 78.0600) 0.1500)
  cqLine77(list(114.9145 83.1400) list(111.4855 83.1400) 0.1500)
  cqLine77(list(100.0573 78.0600) list(103.5427 78.0600) 0.1500)
  cqLine77(list(103.5427 83.1400) list(100.0573 83.1400) 0.1500)
  cqLine77(list(142.6000 100.0000) list(146.2242 100.0000) 0.1016)
  cqLine77(list(148.9758 100.0000) list(152.3492 100.0000) 0.1016)
  cqLine77(list(154.8508 100.0000) list(155.6491 100.0000) 0.1016)
  cqLine77(list(157.5508 100.0000) list(158.6000 100.0000) 0.1016)
  cqLine77(list(146.6000 102.5135) list(146.6000 105.0000) 0.1270)
  cqLine77(list(146.6000 105.0000) list(152.3365 105.0000) 0.1270)
  cqLine77(list(146.6000 95.0000) list(146.6000 97.4865) 0.1270)
  cqLine77(list(92.2000 84.2000) list(91.3000 84.2000) 0.1500)
  cqLine77(list(92.2000 84.2000) list(92.2000 83.3000) 0.1500)
  cqLine77(list(92.2000 75.8000) list(91.3000 75.8000) 0.1500)
  cqLine77(list(92.2000 75.8000) list(92.2000 76.7000) 0.1500)
  cqLine77(list(83.8000 75.8000) list(84.7000 75.8000) 0.1500)
  cqLine77(list(83.8000 75.8000) list(83.8000 76.7000) 0.1500)
  cqLine77(list(83.3000 82.6000) list(83.3000 82.6100) 0.3500)
  cqMoveTxt77("Q1" "*" 0.0 0.3)
  cqMoveTxt77("U15" "*" 0.0 0.3)
  axlShell("drc update")
  p = outfile(strcat(CQDIR "claude_c77.txt"))
  foreach(x reverse(cqLog77) fprintf(p "%s\n" x))
  fprintf(p "NDRC %d\n" length(axlDBGetDesign()->drcs))
  close(p) printf("run77 done log=%d\n" length(cqLog77)) t))
cqRun77()
