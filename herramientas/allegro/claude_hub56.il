; introspect artwork / film API and NC drill (Claude)
CQDIR = "C:/Users/Maria Priscila Quiro/OneDrive/Documentos/Escritorio/Orcad/cdssetup/workspace/projects/hub/"
procedure(cqF56()
  let((p a r)
    p = outfile(strcat(CQDIR "claude_c56.txt"))
    foreach(f '(axlFilmCreate axlDBCreateFilmRec axlfcreate axlFilmDelete axlFilmList axlVisibleDesign axlVisibleLayer axlSetParam axlGetParam axlNCDrill axlRunBatchDBProgram axlArtwork axlFilmMatchDisplay)
      r = errset(arglist(f) nil)
      fprintf(p "FN %s callable=%L args=%L\n" f isCallable(f) r))
    a = car(errset(axlGetParam("artwork") nil))
    fprintf(p "ARTWORK %L\n" (if a a->?? nil))
    foreach(nm list("TOP" "BOTTOM")
      a = car(errset(axlGetParam(strcat("artwork:" nm)) nil))
      fprintf(p "FILM %s %L\n" nm (if a a->?? nil)))
    foreach(d list("c:/cadence/orcadx_25.1/share/pcb/examples/skill/DOC/FUNCS" "c:/cadence/orcadx_25.1/share/pcb/examples/skill/DOC" "c:/cadence/orcadx_25.1/share/pcb/examples/skill" "c:/cadence/orcadx_25.1/share/pcb/examples" "c:/cadence/orcadx_25.1/doc")
      fprintf(p "DIR %s %L\n" d (if isDir(d) length(getDirFiles(d)) nil)))
    close(p) printf("c56 done\n") t))
cqF56()
