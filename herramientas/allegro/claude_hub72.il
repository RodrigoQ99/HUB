; silkscreen / assembly cleanup (Claude) - generated by gen72.py
CQDIR = "C:/Users/Maria Priscila Quiro/OneDrive/Documentos/Escritorio/Orcad/cdssetup/workspace/projects/hub/"
cqB = nil cqLog = nil
procedure(cqMk(name w h cs ls pw)
  let((n) n = car(errset(axlDBTextBlockCreate(1 ?width w ?height h ?lineSpace ls ?charSpace cs ?photoWidth pw) t))
    cqB = cons(list(name n) cqB) n))
procedure(cqBn(name) cadr(assoc(name cqB)))
cqSym = makeTable("cqSym" nil)
foreach(s axlDBGetDesign()->symbols when(s->refdes cqSym[s->refdes] = s))
procedure(cqFind(ref lay)
  let((s res) s = cqSym[ref]
    when(s foreach(c s->children when(c->objType == "text" && c->layer == lay res = c))) res))
procedure(cqSet(ref lay blk rot x y)
  let((tx o r t2 dx dy)
    tx = cqFind(ref lay)
    if(!tx then cqLog = cons(sprintf(nil "MISS %s %s" ref lay) cqLog) nil
    else
      o = make_axlTextOrientation(?textBlock sprintf(nil "%d" cqBn(blk)) ?rotation float(rot) ?mirrored tx->isMirrored ?justify "center")
      r = car(errset(axlDBChangeText(tx nil o) t))
      t2 = cond((null(r) tx) (listp(car(r)) car(car(r))) (t car(r)))
      unless(r cqLog = cons(sprintf(nil "CHG-FAIL %s %s" ref lay) cqLog))
      dx = x - car(t2->xy) dy = y - cadr(t2->xy)
      unless(car(errset(axlTransformObject(t2 ?move list(dx dy)) t)) cqLog = cons(sprintf(nil "MOVE-FAIL %s %s" ref lay) cqLog))
      t)))
procedure(cqDelTxt(ref txt)
  let((s) s = cqSym[ref]
    when(s foreach(c s->children when(c->objType == "text" && c->text == txt && rexMatchp("SILKSCREEN" c->layer)
      axlDeleteObject(c) cqLog = cons(sprintf(nil "DEL %s %s" ref txt) cqLog))))))
procedure(cqFree(txt blk rot x y lay)
  let((o) o = make_axlTextOrientation(?textBlock sprintf(nil "%d" cqBn(blk)) ?rotation float(rot) ?mirrored nil ?justify "center")
    unless(car(errset(axlDBCreateText(txt list(x y) o lay nil) t)) cqLog = cons(sprintf(nil "FREE-FAIL %s" txt) cqLog))))
procedure(cqRun72()
 let((p d)
  cqMk("S1" 0.7500 1.0000 0.2000 1.3000 0.1500)
  cqMk("S2" 0.6000 0.8000 0.1500 1.0500 0.1500)
  cqMk("T1" 0.9000 1.2000 0.2500 1.5500 0.1800)
  cqMk("A035" 0.2625 0.3500 0.0700 0.4550 0.0500)
  cqMk("A045" 0.3375 0.4500 0.0900 0.5850 0.0500)
  cqMk("A060" 0.4500 0.6000 0.1200 0.7800 0.0600)
  cqMk("A080" 0.6000 0.8000 0.1600 1.0400 0.0800)
  cqMk("A100" 0.7500 1.0000 0.2000 1.3000 0.1000)
  cqMk("A120" 0.9000 1.2000 0.2400 1.5600 0.1200)
  cqMk("A150" 1.1250 1.5000 0.3000 1.9500 0.1500)
  if(member(nil mapcar(quote(cadr) cqB)) then printf("BLOCK CREATE FAILED %L\n" cqB) nil else
  cqDelTxt("Q1" "MCP1725T-ADJE/SN")
  cqDelTxt("U15" "MCP1725T-ADJE/SN")
  cqDelTxt("U14" "RPM5.0-6.0")
  cqDelTxt("U16" "TLV62569PDDCR")
  cqDelTxt("SW4" "PTS810_SJM_250_SMTR_LFS")
  cqSet("C1" "REF DES/SILKSCREEN_TOP" "S1" 0 79.5995 101.7432)
  cqSet("C101" "REF DES/SILKSCREEN_TOP" "S1" 0 83.5892 96.9873)
  cqSet("C102" "REF DES/SILKSCREEN_TOP" "S1" 0 78.6505 85.4432)
  cqSet("C103" "REF DES/SILKSCREEN_TOP" "S1" 0 78.6505 92.2070)
  cqSet("C104" "REF DES/SILKSCREEN_TOP" "S1" 0 132.7700 107.0016)
  cqSet("C105" "REF DES/SILKSCREEN_TOP" "S1" 0 128.5558 90.5000)
  cqSet("C106" "REF DES/SILKSCREEN_TOP" "S1" 0 128.5558 93.5000)
  cqSet("C107" "REF DES/SILKSCREEN_TOP" "S1" 0 141.3030 90.5025)
  cqSet("C108" "REF DES/SILKSCREEN_TOP" "S1" 0 149.1510 87.9442)
  cqSet("C109" "REF DES/SILKSCREEN_TOP" "S1" 0 154.0462 83.0000)
  cqSet("C110" "REF DES/SILKSCREEN_TOP" "S1" 0 148.0461 78.8892)
  cqSet("C111" "REF DES/SILKSCREEN_TOP" "S1" 0 130.1495 66.7936)
  cqSet("C112" "REF DES/SILKSCREEN_TOP" "S1" 0 133.9461 61.6892)
  cqSet("C113" "REF DES/SILKSCREEN_TOP" "S1" 90 144.8461 62.6592)
  cqSet("C114" "REF DES/SILKSCREEN_TOP" "S1" 0 140.9495 68.9937)
  cqSet("C115" "REF DES/SILKSCREEN_TOP" "S1" 0 141.0892 71.0025)
  cqSet("C116" "REF DES/SILKSCREEN_TOP" "S1" 0 144.3461 74.2159)
  cqSet("C117" "REF DES/SILKSCREEN_TOP" "S1" 0 156.4112 72.1140)
  cqSet("C118" "REF DES/SILKSCREEN_TOP" "S1" 0 156.4030 68.4026)
  cqSet("C119" "REF DES/SILKSCREEN_TOP" "S1" 0 155.6510 60.9442)
  cqSet("C120" "REF DES/SILKSCREEN_TOP" "S1" 0 150.7558 56.0000)
  cqSet("C121" "REF DES/SILKSCREEN_TOP" "S1" 0 146.5461 50.5892)
  cqSet("C13" "REF DES/SILKSCREEN_TOP" "S1" 0 55.6000 104.3016)
  cqSet("C17" "REF DES/SILKSCREEN_TOP" "S1" 0 122.6000 58.7516)
  cqSet("C44" "REF DES/SILKSCREEN_TOP" "S1" 0 117.6001 85.1639)
  cqSet("C5" "REF DES/SILKSCREEN_TOP" "S1" 0 62.4873 88.6108)
  cqSet("C51" "REF DES/SILKSCREEN_TOP" "S1" 0 89.9409 96.9873)
  cqSet("C52" "REF DES/SILKSCREEN_TOP" "S1" 0 96.6001 99.6862)
  cqSet("C53" "REF DES/SILKSCREEN_TOP" "S1" 90 96.3501 105.5379)
  cqSet("C54" "REF DES/SILKSCREEN_TOP" "S1" 0 57.4682 96.0495)
  cqSet("C58" "REF DES/SILKSCREEN_TOP" "S1" 0 64.7820 102.2995)
  cqSet("C59" "REF DES/SILKSCREEN_TOP" "S1" 0 68.5611 58.8501)
  cqSet("C6" "REF DES/SILKSCREEN_TOP" "S1" 0 64.7942 85.7974)
  cqSet("C60" "REF DES/SILKSCREEN_TOP" "S1" 0 56.6001 60.4872)
  cqSet("C61" "REF DES/SILKSCREEN_TOP" "S1" 90 109.9005 63.1820)
  cqSet("C62" "REF DES/SILKSCREEN_TOP" "S1" 0 67.6001 65.5129)
  cqSet("C63" "REF DES/SILKSCREEN_TOP" "S1" 90 60.9001 56.1622)
  cqSet("C64" "REF DES/SILKSCREEN_TOP" "S1" 0 112.6001 63.3139)
  cqSet("C65" "REF DES/SILKSCREEN_TOP" "S1" 0 95.0001 76.6362)
  cqSet("C67" "REF DES/SILKSCREEN_TOP" "S1" 0 59.1820 81.9005)
  cqSet("C68" "REF DES/SILKSCREEN_TOP" "S1" 0 101.8182 84.3495)
  cqSet("C69" "REF DES/SILKSCREEN_TOP" "S1" 0 91.5182 84.5006)
  cqSet("C70" "REF DES/SILKSCREEN_BOTTOM" "S1" 0 82.6999 81.9139)
  cqSet("C71" "REF DES/SILKSCREEN_BOTTOM" "S1" 0 82.6999 76.2872)
  cqSet("C72" "REF DES/SILKSCREEN_BOTTOM" "S1" 0 83.1621 74.1999)
  cqSet("C73" "REF DES/SILKSCREEN_BOTTOM" "S1" 0 88.7994 72.2430)
  cqSet("C74" "REF DES/SILKSCREEN_BOTTOM" "S1" 0 92.8378 74.1999)
  cqSet("C75" "REF DES/SILKSCREEN_BOTTOM" "S1" 0 95.3001 81.3138)
  cqSet("C76" "REF DES/SILKSCREEN_BOTTOM" "S1" 0 92.8379 84.8001)
  cqSet("C80" "REF DES/SILKSCREEN_BOTTOM" "S1" 0 98.8820 78.4994)
  cqSet("C81" "REF DES/SILKSCREEN_TOP" "S1" 0 94.3001 87.7129)
  cqSet("C82" "REF DES/SILKSCREEN_BOTTOM" "S1" 0 87.0994 76.1568)
  cqSet("C83" "REF DES/SILKSCREEN_BOTTOM" "S1" 0 93.3001 76.2871)
  cqSet("C84" "REF DES/SILKSCREEN_BOTTOM" "S1" 0 88.1505 82.8432)
  cqSet("C85" "REF DES/SILKSCREEN_BOTTOM" "S1" 0 83.2622 84.8001)
  cqSet("C86" "REF DES/SILKSCREEN_BOTTOM" "S1" 0 87.9622 87.6001)
  cqSet("C87" "REF DES/SILKSCREEN_BOTTOM" "S1" 0 83.5611 71.3999)
  cqSet("C88" "REF DES/SILKSCREEN_TOP" "S1" 0 55.2000 50.8984)
  cqSet("C89" "REF DES/SILKSCREEN_TOP" "S1" 0 65.2692 67.7974)
  cqSet("C90" "REF DES/SILKSCREEN_TOP" "S1" 0 59.1820 80.0995)
  cqSet("C91" "REF DES/SILKSCREEN_TOP" "S1" 0 61.9873 70.6108)
  cqSet("C92" "REF DES/SILKSCREEN_TOP" "S1" 0 69.2000 50.4984)
  cqSet("C93" "REF DES/SILKSCREEN_TOP" "S1" 0 83.9409 61.9873)
  cqSet("C94" "REF DES/SILKSCREEN_TOP" "S1" 0 73.2004 64.4570)
  cqSet("C95" "REF DES/SILKSCREEN_TOP" "S1" 0 82.0525 63.9442)
  cqSet("C96" "REF DES/SILKSCREEN_TOP" "S1" 0 107.6000 50.4984)
  cqSet("C97" "REF DES/SILKSCREEN_TOP" "S1" 0 101.9409 62.7373)
  cqSet("C98" "REF DES/SILKSCREEN_TOP" "S1" 90 108.3638 60.1501)
  cqSet("C99" "REF DES/SILKSCREEN_TOP" "S1" 0 96.0642 61.9873)
  cqSet("D1" "REF DES/SILKSCREEN_TOP" "S1" 0 65.7070 106.0995)
  cqSet("D2" "REF DES/SILKSCREEN_TOP" "S1" 0 55.1628 63.9001)
  cqSet("D3" "REF DES/SILKSCREEN_TOP" "S1" 0 62.9505 57.6570)
  cqSet("D4" "REF DES/SILKSCREEN_TOP" "S1" 0 115.4001 51.0872)
  cqSet("D5" "REF DES/SILKSCREEN_TOP" "S1" 0 104.1001 105.6862)
  cqSet("D6" "REF DES/SILKSCREEN_TOP" "S1" 0 106.7070 107.0995)
  cqSet("D7" "REF DES/SILKSCREEN_TOP" "S1" 0 98.3001 104.8862)
  cqSet("D8" "REF DES/SILKSCREEN_TOP" "S1" 0 129.1638 81.1001)
  cqSet("FB1" "REF DES/SILKSCREEN_TOP" "S1" 0 131.7112 71.6140)
  cqSet("FB2" "REF DES/SILKSCREEN_TOP" "S1" 0 152.7112 72.1140)
  cqSet("J5" "REF DES/SILKSCREEN_TOP" "S1" 0 153.0250 106.0750)
  cqSet("L1" "REF DES/SILKSCREEN_TOP" "S1" 0 153.7359 62.5000)
  cqSet("Q1" "REF DES/SILKSCREEN_TOP" "S1" 0 140.0000 96.2604)
  cqSet("R1" "REF DES/SILKSCREEN_TOP" "S1" 0 81.4005 105.6570)
  cqSet("R100" "REF DES/SILKSCREEN_TOP" "S1" 0 103.0995 61.3070)
  cqSet("R102" "REF DES/SILKSCREEN_TOP" "S1" 0 105.9001 87.6139)
  cqSet("R110" "REF DES/SILKSCREEN_TOP" "S1" 90 97.4570 83.2006)
  cqSet("R111" "REF DES/SILKSCREEN_TOP" "S1" 0 88.8727 93.9159)
  cqSet("R112" "REF DES/SILKSCREEN_TOP" "S1" 0 67.2108 88.3727)
  cqSet("R113" "REF DES/SILKSCREEN_TOP" "S1" 0 64.4975 72.3296)
  cqSet("R114" "REF DES/SILKSCREEN_TOP" "S1" 0 79.1273 65.4108)
  cqSet("R115" "REF DES/SILKSCREEN_TOP" "S1" 0 97.1273 65.4108)
  cqSet("R116" "REF DES/SILKSCREEN_TOP" "S1" 0 79.6470 83.4975)
  cqSet("R117" "REF DES/SILKSCREEN_TOP" "S1" 0 83.4039 92.8108)
  cqSet("R118" "REF DES/SILKSCREEN_TOP" "S1" 0 134.3461 96.1892)
  cqSet("R119" "REF DES/SILKSCREEN_TOP" "S1" 0 127.8892 64.9026)
  cqSet("R120" "REF DES/SILKSCREEN_TOP" "S2" 0 144.2642 67.2026)
  cqSet("R121" "REF DES/SILKSCREEN_TOP" "S1" 0 147.6461 63.9892)
  cqSet("R122" "REF DES/SILKSCREEN_TOP" "S1" 0 147.8961 72.4159)
  cqSet("R123" "REF DES/SILKSCREEN_TOP" "S1" 0 143.9336 58.0000)
  cqSet("R124" "REF DES/SILKSCREEN_TOP" "S1" 0 146.5461 55.4159)
  cqSet("R125" "REF DES/SILKSCREEN_TOP" "S1" 0 157.3961 63.0892)
  cqSet("R126" "REF DES/SILKSCREEN_TOP" "S2" 90 159.4030 67.4526)
  cqSet("R20" "REF DES/SILKSCREEN_TOP" "S1" 0 67.8378 97.1001)
  cqSet("R24" "REF DES/SILKSCREEN_TOP" "S1" 0 67.8378 100.1001)
  cqSet("R25" "REF DES/SILKSCREEN_TOP" "S1" 90 65.4005 58.2182)
  cqSet("R26" "REF DES/SILKSCREEN_TOP" "S1" 90 71.2994 66.5820)
  cqSet("R27" "REF DES/SILKSCREEN_TOP" "S1" 0 115.5994 55.9432)
  cqSet("R28" "REF DES/SILKSCREEN_TOP" "S1" 0 117.8378 60.9001)
  cqSet("R29" "REF DES/SILKSCREEN_TOP" "S2" 0 61.4361 59.2501)
  cqSet("R30" "REF DES/SILKSCREEN_TOP" "S1" 0 63.3995 64.8570)
  cqSet("R5" "REF DES/SILKSCREEN_TOP" "S1" 0 57.6932 106.0995)
  cqSet("R58" "REF DES/SILKSCREEN_TOP" "S1" 90 120.3001 83.8379)
  cqSet("R6" "REF DES/SILKSCREEN_TOP" "S1" 0 51.6361 60.9001)
  cqSet("R62" "REF DES/SILKSCREEN_TOP" "S1" 90 93.5432 80.4005)
  cqSet("R66" "REF DES/SILKSCREEN_TOP" "S1" 90 51.7432 82.4005)
  cqSet("R67" "REF DES/SILKSCREEN_TOP" "S1" 0 105.8001 100.6862)
  cqSet("R68" "REF DES/SILKSCREEN_TOP" "S1" 0 101.5001 99.0872)
  cqSet("R69" "REF DES/SILKSCREEN_TOP" "S1" 0 107.9001 77.4872)
  cqSet("R7" "REF DES/SILKSCREEN_TOP" "S1" 0 63.2005 50.5432)
  cqSet("R71" "REF DES/SILKSCREEN_TOP" "S1" 0 108.4001 84.5129)
  cqSet("R72" "REF DES/SILKSCREEN_TOP" "S1" 0 118.0501 77.4872)
  cqSet("R73" "REF DES/SILKSCREEN_TOP" "S1" 90 106.9432 81.5006)
  cqSet("R74" "REF DES/SILKSCREEN_TOP" "S1" 90 125.9005 84.3820)
  cqSet("R8" "REF DES/SILKSCREEN_TOP" "S1" 0 112.4501 53.9139)
  cqSet("R80" "REF DES/SILKSCREEN_TOP" "S1" 0 110.8374 88.2530)
  cqSet("R82" "REF DES/SILKSCREEN_TOP" "S1" 0 120.9974 95.0030)
  cqSet("R88" "REF DES/SILKSCREEN_TOP" "S1" 0 95.5820 96.9005)
  cqSet("R89" "REF DES/SILKSCREEN_TOP" "S1" 0 92.8001 93.7872)
  cqSet("R90" "REF DES/SILKSCREEN_TOP" "S1" 0 62.3001 92.5129)
  cqSet("R91" "REF DES/SILKSCREEN_TOP" "S1" 0 65.4001 92.5129)
  cqSet("R92" "REF DES/SILKSCREEN_TOP" "S1" 0 53.4501 76.6862)
  cqSet("R93" "REF DES/SILKSCREEN_TOP" "S1" 0 59.1820 78.0995)
  cqSet("R94" "REF DES/SILKSCREEN_TOP" "S1" 90 51.7432 79.3495)
  cqSet("R95" "REF DES/SILKSCREEN_TOP" "S1" 90 75.9005 64.3820)
  cqSet("R96" "REF DES/SILKSCREEN_TOP" "S1" 90 79.1628 61.6001)
  cqSet("R97" "REF DES/SILKSCREEN_TOP" "S1" 90 73.7005 57.2182)
  cqSet("R98" "REF DES/SILKSCREEN_TOP" "S1" 0 105.2474 64.6030)
  cqSet("R99" "REF DES/SILKSCREEN_TOP" "S1" 90 108.1975 65.9280)
  cqSet("SW3" "REF DES/SILKSCREEN_TOP" "S1" 0 118.0000 99.2750)
  cqSet("SW4" "REF DES/SILKSCREEN_TOP" "S1" 0 157.4000 52.5000)
  cqSet("U1" "REF DES/SILKSCREEN_TOP" "S1" 0 88.0000 84.0500)
  cqSet("U11" "REF DES/SILKSCREEN_TOP" "S1" 0 101.8000 76.3270)
  cqSet("U12" "REF DES/SILKSCREEN_TOP" "S1" 0 104.6500 104.0000)
  cqSet("U13" "REF DES/SILKSCREEN_TOP" "S1" 0 122.2000 82.5750)
  cqSet("U14" "REF DES/SILKSCREEN_TOP" "S1" 0 139.0000 88.5700)
  cqSet("U15" "REF DES/SILKSCREEN_TOP" "S1" 0 139.0000 62.2604)
  cqSet("U16" "REF DES/SILKSCREEN_TOP" "S1" 0 150.2500 67.9250)
  cqSet("U4" "REF DES/SILKSCREEN_TOP" "S1" 0 60.0750 99.1000)
  cqSet("U5" "REF DES/SILKSCREEN_TOP" "S1" 0 60.4000 63.2750)
  cqSet("U6" "REF DES/SILKSCREEN_TOP" "S1" 90 65.9250 63.6000)
  cqSet("U7" "REF DES/SILKSCREEN_TOP" "S1" 0 112.8500 56.5250)
  cqSet("U8" "REF DES/SILKSCREEN_TOP" "S1" 0 110.4500 76.8350)
  cqSet("Y1" "REF DES/SILKSCREEN_TOP" "S1" 0 82.0000 85.6750)
  cqFree("J12 IN" "S2" 0 91.2520 98.7250 "BOARD GEOMETRY/SILKSCREEN_TOP")
  cqFree("J1 OUT" "S1" 0 63.2250 84.0100 "BOARD GEOMETRY/SILKSCREEN_TOP")
  cqFree("J2 OUT" "S1" 0 63.2250 74.0920 "BOARD GEOMETRY/SILKSCREEN_TOP")
  cqFree("J3 OUT" "S1" 90 85.2900 55.0000 "BOARD GEOMETRY/SILKSCREEN_TOP")
  cqFree("J4 OUT" "S1" 90 91.7100 55.0000 "BOARD GEOMETRY/SILKSCREEN_TOP")
  cqFree("USB-C HUB 1x4  USB5744" "T1" 0 112.1150 70.5900 "BOARD GEOMETRY/SILKSCREEN_TOP")
  cqFree("REV A  10/2026" "S1" 0 112.1150 69.0750 "BOARD GEOMETRY/SILKSCREEN_TOP")
  cqSet("C1" "REF DES/ASSEMBLY_TOP" "A060" 90 79.8995 104.2001)
  cqSet("C101" "REF DES/ASSEMBLY_TOP" "A045" 90 86.5275 97.4873)
  cqSet("C102" "REF DES/ASSEMBLY_TOP" "A045" 90 78.8755 87.9001)
  cqSet("C103" "REF DES/ASSEMBLY_TOP" "A045" 90 78.8755 90.7501)
  cqSet("C104" "REF DES/ASSEMBLY_TOP" "A150" 0 132.7700 102.7500)
  cqSet("C105" "REF DES/ASSEMBLY_TOP" "A120" 0 133.4510 90.4000)
  cqSet("C106" "REF DES/ASSEMBLY_TOP" "A120" 0 133.4510 93.4000)
  cqSet("C107" "REF DES/ASSEMBLY_TOP" "A045" 0 138.0461 90.7776)
  cqSet("C108" "REF DES/ASSEMBLY_TOP" "A120" 0 149.1510 85.9000)
  cqSet("C109" "REF DES/ASSEMBLY_TOP" "A120" 0 149.1510 82.9000)
  cqSet("C110" "REF DES/ASSEMBLY_TOP" "A045" 0 148.0461 80.5776)
  cqSet("C111" "REF DES/ASSEMBLY_TOP" "A060" 0 133.7112 66.9937)
  cqSet("C112" "REF DES/ASSEMBLY_TOP" "A045" 0 133.9461 63.3775)
  cqSet("C113" "REF DES/ASSEMBLY_TOP" "A045" 0 144.3461 65.1476)
  cqSet("C114" "REF DES/ASSEMBLY_TOP" "A060" 0 144.5112 69.1937)
  cqSet("C115" "REF DES/ASSEMBLY_TOP" "A045" 0 144.3461 71.2776)
  cqSet("C116" "REF DES/ASSEMBLY_TOP" "A045" 0 144.3461 73.0776)
  cqSet("C117" "REF DES/ASSEMBLY_TOP" "A060" 0 155.9112 70.6937)
  cqSet("C118" "REF DES/ASSEMBLY_TOP" "A045" 0 153.1461 68.6776)
  cqSet("C119" "REF DES/ASSEMBLY_TOP" "A120" 0 155.6510 58.9000)
  cqSet("C120" "REF DES/ASSEMBLY_TOP" "A120" 0 155.6510 55.9000)
  cqSet("C121" "REF DES/ASSEMBLY_TOP" "A045" 0 146.5461 52.2775)
  cqSet("C13" "REF DES/ASSEMBLY_TOP" "A150" 0 55.6000 100.0500)
  cqSet("C17" "REF DES/ASSEMBLY_TOP" "A150" 0 122.6000 54.5000)
  cqSet("C44" "REF DES/ASSEMBLY_TOP" "A060" 0 117.6001 83.9506)
  cqSet("C5" "REF DES/ASSEMBLY_TOP" "A060" 0 62.4873 87.3975)
  cqSet("C51" "REF DES/ASSEMBLY_TOP" "A060" 90 88.0025 97.4873)
  cqSet("C52" "REF DES/ASSEMBLY_TOP" "A060" 0 96.6001 101.2995)
  cqSet("C53" "REF DES/ASSEMBLY_TOP" "A060" 0 96.6001 102.9995)
  cqSet("C54" "REF DES/ASSEMBLY_TOP" "A060" 0 60.2501 96.2495)
  cqSet("C58" "REF DES/ASSEMBLY_TOP" "A060" 0 62.0001 102.4995)
  cqSet("C59" "REF DES/ASSEMBLY_TOP" "A060" 90 71.0995 60.6001)
  cqSet("C6" "REF DES/ASSEMBLY_TOP" "A060" 0 62.4873 85.9975)
  cqSet("C60" "REF DES/ASSEMBLY_TOP" "A060" 0 56.6001 62.1006)
  cqSet("C61" "REF DES/ASSEMBLY_TOP" "A060" 90 109.7005 60.4001)
  cqSet("C62" "REF DES/ASSEMBLY_TOP" "A060" 0 67.6001 64.2995)
  cqSet("C63" "REF DES/ASSEMBLY_TOP" "A060" 0 60.4001 58.1006)
  cqSet("C64" "REF DES/ASSEMBLY_TOP" "A060" 0 112.6001 62.1006)
  cqSet("C65" "REF DES/ASSEMBLY_TOP" "A060" 0 95.0001 78.2495)
  cqSet("C67" "REF DES/ASSEMBLY_TOP" "A060" 0 56.4001 82.1005)
  cqSet("C68" "REF DES/ASSEMBLY_TOP" "A060" 0 104.6001 84.5495)
  cqSet("C69" "REF DES/ASSEMBLY_TOP" "A060" 0 94.3001 84.7006)
  cqSet("C70" "REF DES/ASSEMBLY_BOTTOM" "A060" 0 82.6999 80.7006)
  cqSet("C71" "REF DES/ASSEMBLY_BOTTOM" "A060" 0 82.6999 77.9005)
  cqSet("C72" "REF DES/ASSEMBLY_BOTTOM" "A035" 0 85.4005 74.5249)
  cqSet("C73" "REF DES/ASSEMBLY_BOTTOM" "A035" 0 88.7995 74.5249)
  cqSet("C74" "REF DES/ASSEMBLY_BOTTOM" "A035" 0 90.5995 74.5249)
  cqSet("C75" "REF DES/ASSEMBLY_BOTTOM" "A060" 0 95.3001 80.1005)
  cqSet("C76" "REF DES/ASSEMBLY_BOTTOM" "A035" 0 90.5995 85.1251)
  cqSet("C80" "REF DES/ASSEMBLY_BOTTOM" "A060" 0 96.1001 78.6994)
  cqSet("C81" "REF DES/ASSEMBLY_TOP" "A060" 0 94.3001 86.4995)
  cqSet("C82" "REF DES/ASSEMBLY_BOTTOM" "A035" 0 87.0995 74.5249)
  cqSet("C83" "REF DES/ASSEMBLY_BOTTOM" "A060" 0 93.3001 77.9005)
  cqSet("C84" "REF DES/ASSEMBLY_BOTTOM" "A035" 0 88.9005 85.1251)
  cqSet("C85" "REF DES/ASSEMBLY_BOTTOM" "A035" 0 85.5006 85.1251)
  cqSet("C86" "REF DES/ASSEMBLY_BOTTOM" "A035" 0 90.2005 87.9251)
  cqSet("C87" "REF DES/ASSEMBLY_BOTTOM" "A035" 0 85.7995 71.7249)
  cqSet("C88" "REF DES/ASSEMBLY_TOP" "A150" 0 55.2000 54.6500)
  cqSet("C89" "REF DES/ASSEMBLY_TOP" "A060" 0 62.4873 67.9975)
  cqSet("C90" "REF DES/ASSEMBLY_TOP" "A060" 0 56.4001 80.2995)
  cqSet("C91" "REF DES/ASSEMBLY_TOP" "A060" 0 62.4873 69.3975)
  cqSet("C92" "REF DES/ASSEMBLY_TOP" "A150" 0 69.2000 54.2500)
  cqSet("C93" "REF DES/ASSEMBLY_TOP" "A060" 90 82.0025 62.4873)
  cqSet("C94" "REF DES/ASSEMBLY_TOP" "A060" 90 73.5005 63.0001)
  cqSet("C95" "REF DES/ASSEMBLY_TOP" "A060" 90 80.6025 62.4873)
  cqSet("C96" "REF DES/ASSEMBLY_TOP" "A150" 0 107.6000 54.2500)
  cqSet("C97" "REF DES/ASSEMBLY_TOP" "A060" 90 100.0025 62.4873)
  cqSet("C98" "REF DES/ASSEMBLY_TOP" "A060" 90 106.7505 60.4001)
  cqSet("C99" "REF DES/ASSEMBLY_TOP" "A060" 90 98.6025 62.4873)
  cqSet("D1" "REF DES/ASSEMBLY_TOP" "A060" 0 63.4001 106.2995)
  cqSet("D2" "REF DES/ASSEMBLY_TOP" "A060" 90 53.6994 64.4001)
  cqSet("D3" "REF DES/ASSEMBLY_TOP" "A060" 90 63.5005 56.2001)
  cqSet("D4" "REF DES/ASSEMBLY_TOP" "A060" 0 115.4001 52.7005)
  cqSet("D5" "REF DES/ASSEMBLY_TOP" "A060" 0 101.6001 107.2995)
  cqSet("D6" "REF DES/ASSEMBLY_TOP" "A060" 0 104.4001 107.2995)
  cqSet("D7" "REF DES/ASSEMBLY_TOP" "A060" 0 98.3001 106.4995)
  cqSet("D8" "REF DES/ASSEMBLY_TOP" "A060" 90 127.7005 81.6001)
  cqSet("FB1" "REF DES/ASSEMBLY_TOP" "A080" 0 131.7112 70.0936)
  cqSet("FB2" "REF DES/ASSEMBLY_TOP" "A080" 0 152.7112 70.5936)
  cqSet("J1" "REF DES/ASSEMBLY_TOP" "A150" 0 55.1500 88.2500)
  cqSet("J12" "REF DES/ASSEMBLY_TOP" "A150" 0 89.0000 104.1000)
  cqSet("J2" "REF DES/ASSEMBLY_TOP" "A150" 0 55.1500 70.2500)
  cqSet("J3" "REF DES/ASSEMBLY_TOP" "A150" 0 79.0000 54.4000)
  cqSet("J4" "REF DES/ASSEMBLY_TOP" "A150" 0 97.0000 54.4000)
  cqSet("J5" "REF DES/ASSEMBLY_TOP" "A150" 0 153.1000 99.2500)
  cqSet("L1" "REF DES/ASSEMBLY_TOP" "A150" 0 149.6954 61.2500)
  cqSet("Q1" "REF DES/ASSEMBLY_TOP" "A150" 0 140.0000 99.2500)
  cqSet("R1" "REF DES/ASSEMBLY_TOP" "A060" 90 81.7005 104.2001)
  cqSet("R100" "REF DES/ASSEMBLY_TOP" "A045" 90 104.8244 59.8501)
  cqSet("R102" "REF DES/ASSEMBLY_TOP" "A045" 0 105.9001 86.4755)
  cqSet("R110" "REF DES/ASSEMBLY_TOP" "A045" 0 95.0001 81.9755)
  cqSet("R111" "REF DES/ASSEMBLY_TOP" "A045" 0 88.8727 92.7776)
  cqSet("R112" "REF DES/ASSEMBLY_TOP" "A045" 90 64.7224 88.8727)
  cqSet("R113" "REF DES/ASSEMBLY_TOP" "A045" 90 64.7224 70.8727)
  cqSet("R114" "REF DES/ASSEMBLY_TOP" "A045" 0 79.1273 64.2725)
  cqSet("R115" "REF DES/ASSEMBLY_TOP" "A045" 0 97.1273 64.2725)
  cqSet("R116" "REF DES/ASSEMBLY_TOP" "A045" 0 82.9039 83.7725)
  cqSet("R117" "REF DES/ASSEMBLY_TOP" "A045" 0 83.4039 91.6725)
  cqSet("R118" "REF DES/ASSEMBLY_TOP" "A045" 0 134.3461 97.8775)
  cqSet("R119" "REF DES/ASSEMBLY_TOP" "A045" 0 131.1461 65.1776)
  cqSet("R120" "REF DES/ASSEMBLY_TOP" "A045" 0 147.1461 67.3775)
  cqSet("R121" "REF DES/ASSEMBLY_TOP" "A045" 0 147.1461 65.6776)
  cqSet("R122" "REF DES/ASSEMBLY_TOP" "A045" 0 147.1461 71.2776)
  cqSet("R123" "REF DES/ASSEMBLY_TOP" "A080" 0 148.0668 58.1000)
  cqSet("R124" "REF DES/ASSEMBLY_TOP" "A045" 0 146.5461 54.2775)
  cqSet("R125" "REF DES/ASSEMBLY_TOP" "A045" 0 157.1461 64.7776)
  cqSet("R126" "REF DES/ASSEMBLY_TOP" "A045" 0 157.1461 66.7276)
  cqSet("R20" "REF DES/ASSEMBLY_TOP" "A060" 90 65.8995 97.6001)
  cqSet("R24" "REF DES/ASSEMBLY_TOP" "A060" 90 65.8995 100.6001)
  cqSet("R25" "REF DES/ASSEMBLY_TOP" "A060" 90 65.4505 61.0001)
  cqSet("R26" "REF DES/ASSEMBLY_TOP" "A060" 90 71.0995 63.8001)
  cqSet("R27" "REF DES/ASSEMBLY_TOP" "A060" 90 115.8995 58.4001)
  cqSet("R28" "REF DES/ASSEMBLY_TOP" "A060" 90 115.8995 61.4001)
  cqSet("R29" "REF DES/ASSEMBLY_TOP" "A060" 90 63.6994 60.4001)
  cqSet("R30" "REF DES/ASSEMBLY_TOP" "A060" 90 63.6994 63.4001)
  cqSet("R5" "REF DES/ASSEMBLY_TOP" "A060" 0 60.0001 106.2995)
  cqSet("R58" "REF DES/ASSEMBLY_TOP" "A060" 0 118.0501 81.2995)
  cqSet("R6" "REF DES/ASSEMBLY_TOP" "A060" 90 53.6994 61.4001)
  cqSet("R62" "REF DES/ASSEMBLY_TOP" "A060" 0 95.0001 80.1005)
  cqSet("R66" "REF DES/ASSEMBLY_TOP" "A060" 0 53.2001 82.1005)
  cqSet("R67" "REF DES/ASSEMBLY_TOP" "A060" 0 105.8001 102.2995)
  cqSet("R68" "REF DES/ASSEMBLY_TOP" "A060" 0 101.5001 100.7006)
  cqSet("R69" "REF DES/ASSEMBLY_TOP" "A060" 0 108.4001 79.1005)
  cqSet("R7" "REF DES/ASSEMBLY_TOP" "A060" 90 63.5005 53.0001)
  cqSet("R71" "REF DES/ASSEMBLY_TOP" "A060" 0 108.4001 83.2995)
  cqSet("R72" "REF DES/ASSEMBLY_TOP" "A060" 0 118.0501 79.1005)
  cqSet("R73" "REF DES/ASSEMBLY_TOP" "A060" 0 108.4001 81.2006)
  cqSet("R74" "REF DES/ASSEMBLY_TOP" "A060" 90 125.7005 81.6001)
  cqSet("R8" "REF DES/ASSEMBLY_TOP" "A060" 0 112.4501 52.7005)
  cqSet("R80" "REF DES/ASSEMBLY_TOP" "A060" 90 111.1375 86.7961)
  cqSet("R82" "REF DES/ASSEMBLY_TOP" "A060" 90 121.2974 93.5461)
  cqSet("R88" "REF DES/ASSEMBLY_TOP" "A060" 0 92.8001 97.1005)
  cqSet("R89" "REF DES/ASSEMBLY_TOP" "A060" 0 92.8001 95.4005)
  cqSet("R90" "REF DES/ASSEMBLY_TOP" "A060" 0 62.3001 91.2995)
  cqSet("R91" "REF DES/ASSEMBLY_TOP" "A060" 0 65.4001 91.2995)
  cqSet("R92" "REF DES/ASSEMBLY_TOP" "A060" 0 53.2001 78.2995)
  cqSet("R93" "REF DES/ASSEMBLY_TOP" "A060" 0 56.4001 78.2995)
  cqSet("R94" "REF DES/ASSEMBLY_TOP" "A060" 0 53.2001 80.2995)
  cqSet("R95" "REF DES/ASSEMBLY_TOP" "A060" 90 75.7005 61.6001)
  cqSet("R96" "REF DES/ASSEMBLY_TOP" "A060" 90 77.5494 61.6001)
  cqSet("R97" "REF DES/ASSEMBLY_TOP" "A060" 90 73.0005 60.0001)
  cqSet("R98" "REF DES/ASSEMBLY_TOP" "A060" 90 106.2974 63.1461)
  cqSet("R99" "REF DES/ASSEMBLY_TOP" "A060" 90 107.9975 63.1461)
  cqSet("SW4" "REF DES/ASSEMBLY_TOP" "A150" 0 152.4000 52.2500)
  cqSet("U1" "REF DES/ASSEMBLY_TOP" "A150" 0 88.0000 79.2500)
  cqSet("U11" "REF DES/ASSEMBLY_TOP" "A150" 0 101.8000 79.8500)
  cqSet("U14" "REF DES/ASSEMBLY_TOP" "A150" 0 138.5975 81.2500)
  cqSet("U15" "REF DES/ASSEMBLY_TOP" "A150" 0 139.0000 65.2500)
  cqSet("U16" "REF DES/ASSEMBLY_TOP" "A100" 0 152.1000 65.5000)
  cqSet("U8" "REF DES/ASSEMBLY_TOP" "A150" 90 113.9500 80.6000)
  p = outfile(strcat(CQDIR "claude_c72.txt"))
  fprintf(p "BLOCKS %L\n" cqB)
  foreach(x reverse(cqLog) fprintf(p "%s\n" x))
  d = axlDBGetDesign()
  foreach(s d->symbols foreach(c s->children when(c->objType == "text" && (rexMatchp("SILKSCREEN" c->layer) || rexMatchp("ASSEMBLY" c->layer))
     fprintf(p "T %s|%s|%s|%L|%L|%L|%L|%L|%L\n" s->refdes c->layer c->text c->xy c->rotation c->isMirrored c->justify c->textBlock c->bBox))))
  foreach(x car(errset(d->text nil)) when(rexMatchp("SILKSCREEN" x->layer) fprintf(p "T -|%s|%s|%L|%L|%L|%L|%L|%L\n" x->layer x->text x->xy x->rotation x->isMirrored x->justify x->textBlock x->bBox)))
  close(p) printf("run72 done log=%d\n" length(cqLog)) t)))
cqRun72()
